simulator lang=spectre

ahdl_include "analog_mux.va"

//////////////////////////////////
// Resistive loads and analog_mux cell //
// v0.1 24/10/2017              //
//////////////////////////////////

subckt resistive_loads (to_rram sel)

	r_255 (n_255 n_254 0) resistor r=2k
	r_254 (n_254 n_253 0) resistor r=2k
	r_253 (n_253 n_252 0) resistor r=2k
	r_252 (n_252 n_251 0) resistor r=2k
	r_251 (n_251 n_250 0) resistor r=2k
	r_250 (n_250 n_249 0) resistor r=2k
	r_249 (n_249 n_248 0) resistor r=2k
	r_248 (n_248 n_247 0) resistor r=2k
	r_247 (n_247 n_246 0) resistor r=2k
	r_246 (n_246 n_245 0) resistor r=2k
	r_245 (n_245 n_244 0) resistor r=2k
	r_244 (n_244 n_243 0) resistor r=2k
	r_243 (n_243 n_242 0) resistor r=2k
	r_242 (n_242 n_241 0) resistor r=2k
	r_241 (n_241 n_240 0) resistor r=2k
	r_240 (n_240 n_239 0) resistor r=2k
	r_239 (n_239 n_238 0) resistor r=2k
	r_238 (n_238 n_237 0) resistor r=2k
	r_237 (n_237 n_236 0) resistor r=2k
	r_236 (n_236 n_235 0) resistor r=2k
	r_235 (n_235 n_234 0) resistor r=2k
	r_234 (n_234 n_233 0) resistor r=2k
	r_233 (n_233 n_232 0) resistor r=2k
	r_232 (n_232 n_231 0) resistor r=2k
	r_231 (n_231 n_230 0) resistor r=2k
	r_230 (n_230 n_229 0) resistor r=2k
	r_229 (n_229 n_228 0) resistor r=2k
	r_228 (n_228 n_227 0) resistor r=2k
	r_227 (n_227 n_226 0) resistor r=2k
	r_226 (n_226 n_225 0) resistor r=2k
	r_225 (n_225 n_224 0) resistor r=2k
	r_224 (n_224 n_223 0) resistor r=2k
	r_223 (n_223 n_222 0) resistor r=2k
	r_222 (n_222 n_221 0) resistor r=2k
	r_221 (n_221 n_220 0) resistor r=2k
	r_220 (n_220 n_219 0) resistor r=2k
	r_219 (n_219 n_218 0) resistor r=2k
	r_218 (n_218 n_217 0) resistor r=2k
	r_217 (n_217 n_216 0) resistor r=2k
	r_216 (n_216 n_215 0) resistor r=2k
	r_215 (n_215 n_214 0) resistor r=2k
	r_214 (n_214 n_213 0) resistor r=2k
	r_213 (n_213 n_212 0) resistor r=2k
	r_212 (n_212 n_211 0) resistor r=2k
	r_211 (n_211 n_210 0) resistor r=2k
	r_210 (n_210 n_209 0) resistor r=2k
	r_209 (n_209 n_208 0) resistor r=2k
	r_208 (n_208 n_207 0) resistor r=2k
	r_207 (n_207 n_206 0) resistor r=2k
	r_206 (n_206 n_205 0) resistor r=2k
	r_205 (n_205 n_204 0) resistor r=2k
	r_204 (n_204 n_203 0) resistor r=2k
	r_203 (n_203 n_202 0) resistor r=2k
	r_202 (n_202 n_201 0) resistor r=2k
	r_201 (n_201 n_200 0) resistor r=2k
	r_200 (n_200 n_199 0) resistor r=2k
	r_199 (n_199 n_198 0) resistor r=2k
	r_198 (n_198 n_197 0) resistor r=2k
	r_197 (n_197 n_196 0) resistor r=2k
	r_196 (n_196 n_195 0) resistor r=2k
	r_195 (n_195 n_194 0) resistor r=2k
	r_194 (n_194 n_193 0) resistor r=2k
	r_193 (n_193 n_192 0) resistor r=2k
	r_192 (n_192 n_191 0) resistor r=2k
	r_191 (n_191 n_190 0) resistor r=2k
	r_190 (n_190 n_189 0) resistor r=2k
	r_189 (n_189 n_188 0) resistor r=2k
	r_188 (n_188 n_187 0) resistor r=2k
	r_187 (n_187 n_186 0) resistor r=2k
	r_186 (n_186 n_185 0) resistor r=2k
	r_185 (n_185 n_184 0) resistor r=2k
	r_184 (n_184 n_183 0) resistor r=2k
	r_183 (n_183 n_182 0) resistor r=2k
	r_182 (n_182 n_181 0) resistor r=2k
	r_181 (n_181 n_180 0) resistor r=2k
	r_180 (n_180 n_179 0) resistor r=2k
	r_179 (n_179 n_178 0) resistor r=2k
	r_178 (n_178 n_177 0) resistor r=2k
	r_177 (n_177 n_176 0) resistor r=2k
	r_176 (n_176 n_175 0) resistor r=2k
	r_175 (n_175 n_174 0) resistor r=2k
	r_174 (n_174 n_173 0) resistor r=2k
	r_173 (n_173 n_172 0) resistor r=2k
	r_172 (n_172 n_171 0) resistor r=2k
	r_171 (n_171 n_170 0) resistor r=2k
	r_170 (n_170 n_169 0) resistor r=2k
	r_169 (n_169 n_168 0) resistor r=2k
	r_168 (n_168 n_167 0) resistor r=2k
	r_167 (n_167 n_166 0) resistor r=2k
	r_166 (n_166 n_165 0) resistor r=2k
	r_165 (n_165 n_164 0) resistor r=2k
	r_164 (n_164 n_163 0) resistor r=2k
	r_163 (n_163 n_162 0) resistor r=2k
	r_162 (n_162 n_161 0) resistor r=2k
	r_161 (n_161 n_160 0) resistor r=2k
	r_160 (n_160 n_159 0) resistor r=2k
	r_159 (n_159 n_158 0) resistor r=2k
	r_158 (n_158 n_157 0) resistor r=2k
	r_157 (n_157 n_156 0) resistor r=2k
	r_156 (n_156 n_155 0) resistor r=2k
	r_155 (n_155 n_154 0) resistor r=2k
	r_154 (n_154 n_153 0) resistor r=2k
	r_153 (n_153 n_152 0) resistor r=2k
	r_152 (n_152 n_151 0) resistor r=2k
	r_151 (n_151 n_150 0) resistor r=2k
	r_150 (n_150 n_149 0) resistor r=2k
	r_149 (n_149 n_148 0) resistor r=2k
	r_148 (n_148 n_147 0) resistor r=2k
	r_147 (n_147 n_146 0) resistor r=2k
	r_146 (n_146 n_145 0) resistor r=2k
	r_145 (n_145 n_144 0) resistor r=2k
	r_144 (n_144 n_143 0) resistor r=2k
	r_143 (n_143 n_142 0) resistor r=2k
	r_142 (n_142 n_141 0) resistor r=2k
	r_141 (n_141 n_140 0) resistor r=2k
	r_140 (n_140 n_139 0) resistor r=2k
	r_139 (n_139 n_138 0) resistor r=2k
	r_138 (n_138 n_137 0) resistor r=2k
	r_137 (n_137 n_136 0) resistor r=2k
	r_136 (n_136 n_135 0) resistor r=2k
	r_135 (n_135 n_134 0) resistor r=2k
	r_134 (n_134 n_133 0) resistor r=2k
	r_133 (n_133 n_132 0) resistor r=2k
	r_132 (n_132 n_131 0) resistor r=2k
	r_131 (n_131 n_130 0) resistor r=2k
	r_130 (n_130 n_129 0) resistor r=2k
	r_129 (n_129 n_128 0) resistor r=2k
	r_128 (n_128 n_127 0) resistor r=2k
	r_127 (n_127 n_126 0) resistor r=2k
	r_126 (n_126 n_125 0) resistor r=2k
	r_125 (n_125 n_124 0) resistor r=2k
	r_124 (n_124 n_123 0) resistor r=2k
	r_123 (n_123 n_122 0) resistor r=2k
	r_122 (n_122 n_121 0) resistor r=2k
	r_121 (n_121 n_120 0) resistor r=2k
	r_120 (n_120 n_119 0) resistor r=2k
	r_119 (n_119 n_118 0) resistor r=2k
	r_118 (n_118 n_117 0) resistor r=2k
	r_117 (n_117 n_116 0) resistor r=2k
	r_116 (n_116 n_115 0) resistor r=2k
	r_115 (n_115 n_114 0) resistor r=2k
	r_114 (n_114 n_113 0) resistor r=2k
	r_113 (n_113 n_112 0) resistor r=2k
	r_112 (n_112 n_111 0) resistor r=2k
	r_111 (n_111 n_110 0) resistor r=2k
	r_110 (n_110 n_109 0) resistor r=2k
	r_109 (n_109 n_108 0) resistor r=2k
	r_108 (n_108 n_107 0) resistor r=2k
	r_107 (n_107 n_106 0) resistor r=2k
	r_106 (n_106 n_105 0) resistor r=2k
	r_105 (n_105 n_104 0) resistor r=2k
	r_104 (n_104 n_103 0) resistor r=2k
	r_103 (n_103 n_102 0) resistor r=2k
	r_102 (n_102 n_101 0) resistor r=2k
	r_101 (n_101 n_100 0) resistor r=2k
	r_100 (n_100 n_99 0) resistor r=2k
	r_99 (n_99 n_98 0) resistor r=2k
	r_98 (n_98 n_97 0) resistor r=2k
	r_97 (n_97 n_96 0) resistor r=2k
	r_96 (n_96 n_95 0) resistor r=2k
	r_95 (n_95 n_94 0) resistor r=2k
	r_94 (n_94 n_93 0) resistor r=2k
	r_93 (n_93 n_92 0) resistor r=2k
	r_92 (n_92 n_91 0) resistor r=2k
	r_91 (n_91 n_90 0) resistor r=2k
	r_90 (n_90 n_89 0) resistor r=2k
	r_89 (n_89 n_88 0) resistor r=2k
	r_88 (n_88 n_87 0) resistor r=2k
	r_87 (n_87 n_86 0) resistor r=2k
	r_86 (n_86 n_85 0) resistor r=2k
	r_85 (n_85 n_84 0) resistor r=2k
	r_84 (n_84 n_83 0) resistor r=2k
	r_83 (n_83 n_82 0) resistor r=2k
	r_82 (n_82 n_81 0) resistor r=2k
	r_81 (n_81 n_80 0) resistor r=2k
	r_80 (n_80 n_79 0) resistor r=2k
	r_79 (n_79 n_78 0) resistor r=2k
	r_78 (n_78 n_77 0) resistor r=2k
	r_77 (n_77 n_76 0) resistor r=2k
	r_76 (n_76 n_75 0) resistor r=2k
	r_75 (n_75 n_74 0) resistor r=2k
	r_74 (n_74 n_73 0) resistor r=2k
	r_73 (n_73 n_72 0) resistor r=2k
	r_72 (n_72 n_71 0) resistor r=2k
	r_71 (n_71 n_70 0) resistor r=2k
	r_70 (n_70 n_69 0) resistor r=2k
	r_69 (n_69 n_68 0) resistor r=2k
	r_68 (n_68 n_67 0) resistor r=2k
	r_67 (n_67 n_66 0) resistor r=2k
	r_66 (n_66 n_65 0) resistor r=2k
	r_65 (n_65 n_64 0) resistor r=2k
	r_64 (n_64 n_63 0) resistor r=2k
	r_63 (n_63 n_62 0) resistor r=2k
	r_62 (n_62 n_61 0) resistor r=2k
	r_61 (n_61 n_60 0) resistor r=2k
	r_60 (n_60 n_59 0) resistor r=2k
	r_59 (n_59 n_58 0) resistor r=2k
	r_58 (n_58 n_57 0) resistor r=2k
	r_57 (n_57 n_56 0) resistor r=2k
	r_56 (n_56 n_55 0) resistor r=2k
	r_55 (n_55 n_54 0) resistor r=2k
	r_54 (n_54 n_53 0) resistor r=2k
	r_53 (n_53 n_52 0) resistor r=2k
	r_52 (n_52 n_51 0) resistor r=2k
	r_51 (n_51 n_50 0) resistor r=2k
	r_50 (n_50 n_49 0) resistor r=2k
	r_49 (n_49 n_48 0) resistor r=2k
	r_48 (n_48 n_47 0) resistor r=2k
	r_47 (n_47 n_46 0) resistor r=2k
	r_46 (n_46 n_45 0) resistor r=2k
	r_45 (n_45 n_44 0) resistor r=2k
	r_44 (n_44 n_43 0) resistor r=2k
	r_43 (n_43 n_42 0) resistor r=2k
	r_42 (n_42 n_41 0) resistor r=2k
	r_41 (n_41 n_40 0) resistor r=2k
	r_40 (n_40 n_39 0) resistor r=2k
	r_39 (n_39 n_38 0) resistor r=2k
	r_38 (n_38 n_37 0) resistor r=2k
	r_37 (n_37 n_36 0) resistor r=2k
	r_36 (n_36 n_35 0) resistor r=2k
	r_35 (n_35 n_34 0) resistor r=2k
	r_34 (n_34 n_33 0) resistor r=2k
	r_33 (n_33 n_32 0) resistor r=2k
	r_32 (n_32 n_31 0) resistor r=2k
	r_31 (n_31 n_30 0) resistor r=2k
	r_30 (n_30 n_29 0) resistor r=2k
	r_29 (n_29 n_28 0) resistor r=2k
	r_28 (n_28 n_27 0) resistor r=2k
	r_27 (n_27 n_26 0) resistor r=2k
	r_26 (n_26 n_25 0) resistor r=2k
	r_25 (n_25 n_24 0) resistor r=2k
	r_24 (n_24 n_23 0) resistor r=2k
	r_23 (n_23 n_22 0) resistor r=2k
	r_22 (n_22 n_21 0) resistor r=2k
	r_21 (n_21 n_20 0) resistor r=2k
	r_20 (n_20 n_19 0) resistor r=2k
	r_19 (n_19 n_18 0) resistor r=2k
	r_18 (n_18 n_17 0) resistor r=2k
	r_17 (n_17 n_16 0) resistor r=2k
	r_16 (n_16 n_15 0) resistor r=2k
	r_15 (n_15 n_14 0) resistor r=2k
	r_14 (n_14 n_13 0) resistor r=2k
	r_13 (n_13 n_12 0) resistor r=2k
	r_12 (n_12 n_11 0) resistor r=2k
	r_11 (n_11 n_10 0) resistor r=2k
	r_10 (n_10 n_9 0) resistor r=2k
	r_9 (n_9 n_8 0) resistor r=2k
	r_8 (n_8 n_7 0) resistor r=2k
	r_7 (n_7 n_6 0) resistor r=2k
	r_6 (n_6 n_5 0) resistor r=2k
	r_5 (n_5 n_4 0) resistor r=2k
	r_4 (n_4 n_3 0) resistor r=2k
	r_3 (n_3 n_2 0) resistor r=2k
	r_2 (n_2 n_1 0) resistor r=2k
	r_1 (n_1 n_0 0) resistor r=2k
	r_0 (n_0 0 0) resistor r=2k

	// analog_mux connection

	m_0 (n_255 n_254 n_253 n_252 n_251 n_250
		+ n_249 n_248 n_247 n_246 n_245 n_244 n_243 n_242 n_241 n_240
		+ n_239 n_238 n_237 n_236 n_235 n_234 n_233 n_232 n_231 n_230
		+ n_229 n_228 n_227 n_226 n_225 n_224 n_223 n_222 n_221 n_220
		+ n_219 n_218 n_217 n_216 n_215 n_214 n_213 n_212 n_211 n_210
		+ n_209 n_208 n_207 n_206 n_205 n_204 n_203 n_202 n_201 n_200
		+ n_199 n_198 n_197 n_196 n_195 n_194 n_193 n_192 n_191 n_190
		+ n_189 n_188 n_187 n_186 n_185 n_184 n_183 n_182 n_181 n_180
		+ n_179 n_178 n_177 n_176 n_175 n_174 n_173 n_172 n_171 n_170
		+ n_169 n_168 n_167 n_166 n_165 n_164 n_163 n_162 n_161 n_160
		+ n_159 n_158 n_157 n_156 n_155 n_154 n_153 n_152 n_151 n_150
		+ n_149 n_148 n_147 n_146 n_145 n_144 n_143 n_142 n_141 n_140
		+ n_139 n_138 n_137 n_136 n_135 n_134 n_133 n_132 n_131 n_130
		+ n_129 n_128 n_127 n_126 n_125 n_124 n_123 n_122 n_121 n_120
		+ n_119 n_118 n_117 n_116 n_115 n_114 n_113 n_112 n_111 n_110
		+ n_109 n_108 n_107 n_106 n_105 n_104 n_103 n_102 n_101 n_100
		+ n_99 n_98 n_97 n_96 n_95 n_94 n_93 n_92 n_91 n_90
		+ n_89 n_88 n_87 n_86 n_85 n_84 n_83 n_82 n_81 n_80
		+ n_79 n_78 n_77 n_76 n_75 n_74 n_73 n_72 n_71 n_70
		+ n_69 n_68 n_67 n_66 n_65 n_64 n_63 n_62 n_61 n_60
		+ n_59 n_58 n_57 n_56 n_55 n_54 n_53 n_52 n_51 n_50
		+ n_49 n_48 n_47 n_46 n_45 n_44 n_43 n_42 n_41 n_40
		+ n_39 n_38 n_37 n_36 n_35 n_34 n_33 n_32 n_31 n_30
		+ n_29 n_28 n_27 n_26 n_25 n_24 n_23 n_22 n_21 n_20
		+ n_19 n_18 n_17 n_16 n_15 n_14 n_13 n_12 n_11 n_10
		+ n_9 n_8 n_7 n_6 n_5 n_4 n_3 n_2 n_1 n_0
		+  to_rram sel) analog_mux

ends resistive_loads
