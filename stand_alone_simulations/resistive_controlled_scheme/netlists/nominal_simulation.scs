simulator lang=spectre

include "r0_paramset.scs"

// simulation
// + sim_max_step=0.5ns sim_step=0.3ns + sim_max_step= 1u
parameters fw_firstrun=1 fw_seed=1 fw_numruns=10

// writing starts at 1u
// psettiming paramset {
// 	time maxstep
// 	0  	0.5u
// 	9n 0.001n
// }

// Start of reliability_montecarlo (montecarlo) analysis
// reliability_montecarlo montecarlo variations=all donominal=no savefamilyplots=yes firstrun=fw_firstrun seed=fw_seed numruns=fw_numruns {

// mc1 montecarlo numruns=10 seed=12345 variations=all sampling=standard \
// 	donominal=yes scalarfile="../monteCarlo/mcdata" \
// 	paramfile="../monteCarlo/mcparam" saveprocessparams=yes \
// 	processparamfile="../monteCarlo/processParam" \
// 	processscalarfile="../monteCarlo/processData" savemismatchparams=yes \
// 	dependencymapfile="../monteCarlo/mismatchdependency" \
// 	dumpdependency=mismatch \
// 	dependencyscalarfile="../monteCarlo/compactmismatchdata" \
// 	dependencyparamfile="../monteCarlo/compactmismatchparam"  \
// 	paramdumpmode=yes savefamilyplots=yes savedatainseparatedir=yes \
// 	wfseparation=yes {

	// Start of sensible_nodes_sweep (sweep) analysis

	// with paramset
	// rram_sweep sweep paramset=r0_paramset {

	// no paramset
	rram_sweep sweep param=p_level start=0 stop=p_total_levels step=1{
	// rram_sweep sweep param=p_tx_p_l start=40n stop=1.5u dec=5{
		// Start of reliability_framework_tran (tran) analysis
		reliability_framework_tran tran save=selected stop=p_sim_time
			+ method=gear2only annotate=no maxiters=5
			+ maxstep=p_max_step
			// + paramset=psettiming
	}

// }// End of reliability_montecarlo (montecarlo ) analysis
mcOptions options genmcdep=yes

// Old options (TVLSI)
// simulation options
// simulatorOptions options temp=mT0Celsius genmcdep=yes
// + tnom=27 scale=1.0 gmin=1e-12 rforce=1 maxnotes=5 maxwarns=5 digits=5 cols=80 pivrel=1e-3
// + reltol=1e-8 vabstol=1e-9 iabstol=1e-11
// + reltol=1e-9 vabstol=1e-10 iabstol=1e-12

// New options
simulatorOptions options temp=p_temp tnom=27 scale=1.0 gmin=1e-12 rforce=1 maxnotes=5 maxwarns=5 digits=5 cols=80
		// + reltol=1e-8 vabstol=1e-9 iabstol=1e-11
		// + pivrel=1e-3 reltol=1e-10 vabstol=1e-10 iabstol=1e-13 // used for characterization
		// + pivrel=1e-3 reltol=1e-10 vabstol=1e-10 iabstol=1e-13

saveOptions options save=selected saveahdlvars=selected

// save statements
save n_write
save n_gate

// save n_level
// save n_control_0

//////////////////
// Resistive loads and analog mux
//////////////////
// save rl_0.m_0:select
// save rl_0.m_0:in
// save rl_0.m_0:v_in

// save rl_0.n_0
// save rl_0.n_1
// save rl_0.n_2
// save rl_0.n_3
// save rl_0.n_4
// save rl_0.n_5
// save rl_0.n_6
// save rl_0.n_7
// save rl_0.to_ram

//////////////////
// Parasitics
//////////////////
// save rram_0.tx_src
// save rram_0.tx_drain
// save rram_0.mid1
// save rram_0.mid2

//////////////////
// rram 0
//////////////////
// save rram_0.mem_0:gap_ddt
// save rram_0.mem_0:rram_g
// save rram_0.mem_0:rram_temperature
// save rram_0.mem_0:rram_v
// save rram_0.mem_0:rram_i
// save rram_0.mem_0:rram_r
// save rram_0.mem_0:rram_r_read

save rram_0.mem_0:rram_r_read
save rram_1.mem_0:rram_r_read
save rram_2.mem_0:rram_r_read
save rram_3.mem_0:rram_r_read
save rram_4.mem_0:rram_r_read
save rram_5.mem_0:rram_r_read
