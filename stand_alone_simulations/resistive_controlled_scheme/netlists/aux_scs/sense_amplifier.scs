simulator lang=spectre

// sense_amplifier/low_signals_sense_amplifier/schematic
subckt low_signals_sense_amplifier bl blb out_data saen
    M15 (0 saen node_1 0) nch_hvt_mac l=40n w=120.0n multi=1 nf=1
    M14 (0 saen node_2 0) nch_hvt_mac l=40n w=120.0n multi=1 nf=1
    M12 (0 node_2 node_1 0) nch_hvt_mac l=80n w=320.0n multi=1 nf=1
    M11 (0 node_1 node_2 0) nch_hvt_mac l=40n w=320.0n multi=1 nf=1
    M18 (net9 saen vdd! vdd!) pch_hvt_mac l=40n w=10u multi=10 nf=1
    M17 (node_2 bl net9 vdd!) pch_hvt_mac l=40n w=480.0n multi=1 nf=1
    M16 (node_1 blb net9 vdd!) pch_hvt_mac l=80n w=480.0n multi=1 nf=1
    M1 (out_data node_2 0 0) nch_mac l=40n w=120n multi=1 nf=1
    M0 (out_data node_2 vdd! vdd!) pch_mac l=40n w=240.0n multi=1 nf=1
ends low_signals_sense_amplifier
