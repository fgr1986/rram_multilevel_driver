//////////////////////////
// Single rram 1R cell //
// v0.2 14/12/2016     //
//////////////////////////

simulator lang=spectre

ahdl_include "stanford_memristor.vams"

/////////////////////////////////////////////
// Subcircuit and Parameters
/////////////////////////////////////////////

subckt rram_cell_1r (plus minus)

	parameters rram_R1=20 rram_Rh=2e9 rram_Cp=1f rram_R2=20
	+ rram_T0=300
	// LRS
	// + rram_X0=0 rram_W0=5e-9
	// HRS
	+ rram_X0=3e-9 rram_W0=0.5e-9

	// Parasitic elements
	R1 (plus mid1) resistor r=rram_R1
	Rh (mid1 mid2) resistor r=rram_Rh
	Cp (mid1 mid2) capacitor c=rram_Cp
	// memristor
	mem_0 (mid1 mid2) memristor T0=rram_T0 x0=rram_X0 w0=rram_W0
	R2 (mid2 minus) resistor r=rram_R2

	// energy (if required)
	// Een ( energy 0 ) bsource v=idt( v(plus, minus)*i(R1), 0 )

ends rram_cell_1r
