simulator lang=spectre

r0_paramset paramset {
	p_r0
	1k
	2k
	5k
	8k
	11.5k
	20k
	50k
	100K
	500k
}

// r0_paramset paramset {
// 	p_r0
// 	5k
// 	50k
// 	100k
// 	500k
// 	700k
// 	1000k
// 	2000k
// 	3000k
// 	4000k
// }
