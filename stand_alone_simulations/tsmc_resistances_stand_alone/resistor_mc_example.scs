// Design: test_fgarcia/test_resistor
simulator lang=spectre
global 0
parameters m_dc=2

// Including parsed model. Original: '/opt/technology/tsmc40nm_18/models/spectre/toplevel.scs'
include "/opt/technology/tsmc40nm_18/models/spectre/toplevel.scs" section=top_globalmc_localmc

// ahdl_include "ommit/mux2.va"

// test_fgarcia/test_resistor/schematic

// R1 (a\<2\> 0 0 ) rppolyl_m lr=100.0000u wr=4u multi=(1) m=1
// R0 (a\<1\> 0 0 ) rppolyl_m lr=100.0000u wr=2u multi=(1) m=1

// all are 5k
R0 (net3_0 0 0 ) rppolywo_m lr=15.78u wr=2u multi=(1) m=1
R1 (net3_1 0 0 ) rppolywo_m lr=15.78u wr=2u multi=(1) m=1

// m0 (net3_0, net3_1, v_w, v_c) mux2

V0 (net3_0 0) vsource dc=m_dc type=dc
V1 (net3_1 0) vsource dc=m_dc type=dc

simulatorOptions options temp=27
mc1 montecarlo numruns=10 seed=12345 variations=all sampling=standard donominal=yes scalarfile="../monteCarlo/mcdata" paramfile="../monteCarlo/mcparam" saveprocessparams=yes processparamfile="../monteCarlo/processParam" processscalarfile="../monteCarlo/processData" savemismatchparams=no savefamilyplots=yes savedatainseparatedir=yes wfseparation=yes {
dc dc param=m_dc start=0 stop=3
export noExprs=oceanEval("0")
}
save R0:1 R1:1 R3:1 R2:1
