// Design: tsmc_resistances_test/resistances_test
simulator lang=spectre
global 0
// Simulate with // top_globalmc_localmc // top_localmconly
include "/opt/technology/tsmc40nm_18/tsmcN40/../models/spectre/toplevel.scs" section=top_globalmc_localmc

// tsmc_resistances_test/resistances_test/schematic

// Poly resistor
// R0 (net02 0 0 ) rppolyl_m lr=100.0000u wr=2u multi=(1) m=1

// Required resistor
R1 (net02 0 0 ) rnwsti_m lr=10u wr=2u // multi=(1) m=1

V0 (net02 0) vsource type=pulse delay=5n val0=100.0m val1=3 rise=10n fall=10n width=0

simulatorOptions options temp=27
mc1 montecarlo numruns=100 seed=12345 variations=mismatch sampling=standard donominal=yes scalarfile="../monteCarlo/mcdata" paramfile="../monteCarlo/mcparam" saveprocessparams=yes processparamfile="../monteCarlo/processParam" processscalarfile="../monteCarlo/processData" savemismatchparams=yes dependencymapfile="../monteCarlo/mismatchdependency" dumpdependency=mismatch dependencyscalarfile="../monteCarlo/compactmismatchdata" dependencyparamfile="../monteCarlo/compactmismatchparam" paramdumpmode=yes savefamilyplots=yes savedatainseparatedir=yes wfseparation=yes {
tran tran stop=50n
export noExprs=oceanEval("0")
}
mcOptions options genmcdep=yes
save R1:1
