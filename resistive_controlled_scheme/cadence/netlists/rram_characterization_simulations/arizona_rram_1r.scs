////////////////////////////
// Single rram experiment //
// v1.0 06/11/2017        //
////////////////////////////

simulator lang=spectre
global 0 vdd! vss!

// technology files
include "/opt/technology/tsmc40nm_18/tsmcN40/../models/spectre/toplevel.scs" section=top_localmconly

// RRAM files
include "../ommit/arizona_rram_cells.scs"
// simulation files
include "rram_characterization_simulation.scs"

// Parameters
parameters

// simulation
+ p_sim_time=30n + p_write_length
// + p_max_step=10p
+ p_max_step=1000p
// temperature
+ p_T0=300
+ p_temp=(p_T0-273.15) // in celsius

// rram initial state
+ p_gamma0=16.5
// Roff->Ron For set (3.68M)
// + p_rram_gap_ini=1.367e-9
// + p_rram_gap_ini_0=0.2e-9
// + p_rram_gap_ini_1=0.1367e-9
+ p_rram_gap_ini_0=1.7e-9
+ p_rram_gap_ini_0=0.1e-9

// vdd
+ p_vdd=1.8
// write pulse
+ p_up=5n p_fall=5n p_delay=10n p_write_length=100n
// write amp nominal
+ p_v_set=1.8 // fom simulations
+ p_write_amp=-2*p_v_set

// voltage supply
VDD      ( vdd!     0 ) vsource dc=p_vdd type=dc
VSS      ( vss!     0 ) vsource dc=0     type=dc

// set characterization voltage
Vcar (n_write 0) vsource type=pulse delay=p_delay val0=0 val1=p_write_amp rise=p_write_length/2 fall=p_write_length/2 width=p_write_length

// cell no parasitics
rram_0 (n_write 0)  rram_cell_1r_no_parasitics rram_T0=p_T0 rram_gap_ini=p_rram_gap_ini_0 rram_gamma0=p_gamma0
// with parasitics
// rram_0 (n_write 0)  rram_cell_1r rram_T0=p_T0 rram_gap_ini=p_rram_gap_ini_0
