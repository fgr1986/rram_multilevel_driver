////////////////////////////
// Single rram experiment //
// v0.1 28/09/2017        //
////////////////////////////

simulator lang=spectre
global 0 vdd! vss!

// Including parsed model. Original: '/opt/technology/tsmc40nm_18/models/spectre/toplevel.scs'
// top_localmconly top_tt
// include "/opt/technology/tsmc40nm_18/models/spectre/toplevel.scs" section=top_localmconly
include "/opt/technology/tsmc40nm_18/tsmcN40/../models/spectre/toplevel.scs" section=top_localmconly

include "../ommit/arizona_rram_cells.scs"
include "../ommit/montecarlo/full_range_r_read/1r_g_idx_0_loads_subcircuit.scs"
include "montecarlo_simulation.scs"

// Parameters
parameters

// simulation
+ p_sim_time=30n + p_write_length
// + p_max_step=10p
// + p_max_step=1000p
// temperature
+ p_T0=300
+ p_temp=(p_T0-273.15) // in celsius

// rram initial state
+ p_gamma0=16.5
// Roff->Ron For set (3.68M)
// + p_rram_gap_ini=1.7e-9
// Roff->Ron For set (1M)
// + p_rram_gap_ini_0b=1.367e-9
// + p_rram_gap_ini_0b=1.7e-9
// + p_rram_gap_ini_0b=1.177e-9
+ p_rram_gap_ini_0b=1.2e-9
+ p_rram_gap_ini_0=max(0.1e-9, min(p_rram_gap_ini_0b, 1.7e-9))

// level
+ p_level=100
+ p_total_levels=32-1 // for sweep

// resistances
// p_r0 adds variability
+ p_r0=1

// vdd
+ p_vdd=1.8
// write pulse
+ p_up=5n p_fall=5n p_delay=10n p_write_length=100n
// write amp nominal
+ p_v_set=1.8 // fom simulations
+ p_write_amp=p_level<p_total_levels ? 2*p_v_set : 0

// voltage supply
VDD      ( vdd!     0 ) vsource dc=p_vdd type=dc
VSS      ( vss!     0 ) vsource dc=0     type=dc

// write voltage (pulse)
V0 (n_write 0) vsource type=pulse delay=p_delay val0=0 val1=p_write_amp rise=p_up fall=p_fall width=p_write_length

////////////////////////////
// Write circuit
////////////////////////////
// Memristor
// 1R no parasitics
// rram_0 (n_write n_control_0)  rram_cell_1r_no_parasitics rram_T0=p_T0 rram_gap_ini=p_rram_gap_ini_0
// 1R with parasitics
rram_0 (n_write n_control_0)  rram_cell_1r rram_T0=p_T0 rram_gamma0=p_gamma0 rram_gap_ini=p_rram_gap_ini_0

// resistor loads
rl_0 (n_control_0) resistive_loads mux_level=p_level
