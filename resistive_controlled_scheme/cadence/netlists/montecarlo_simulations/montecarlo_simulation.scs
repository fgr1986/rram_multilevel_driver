simulator lang=spectre

// include "r0_paramset.scs"

// simulation
parameters fw_firstrun=1 fw_seed=12345 fw_numruns=100

// Variability is modeled ussing gamma0 parameter, according to
// Chen, P., & Yu, S. (2015). Compact Modeling of RRAM Devices and Its Applications in 1T1R and 1S1R Array Design.
// IEEE Transactions on Electron Devices, 62(12), 4022–4028. https://doi.org/10.1109/TED.2015.2492421

// memristor variability
statistics{
	process{
		vary p_rram_gap_ini_0 dist=gauss std=1 percent=yes
		vary p_gamma0 dist=gauss std=0.5 percent=yes
	}
}

// Start of reliability_montecarlo (montecarlo) analysis
reliability_montecarlo montecarlo variations=all donominal=yes \
	savefamilyplots=yes firstrun=fw_firstrun seed=fw_seed numruns=fw_numruns \
	// scalarfile="../monteCarlo/mcdata" \
	// paramfile="../monteCarlo/mcparam" saveprocessparams=yes \
	// processparamfile="../monteCarlo/processParam" \
	// processscalarfile="../monteCarlo/processData" savemismatchparams=yes \
	// dependencymapfile="../monteCarlo/mismatchdependency" \
	// dumpdependency=mismatch \
	// dependencyscalarfile="../monteCarlo/compactmismatchdata" \
	// dependencyparamfile="../monteCarlo/compactmismatchparam"  \
	// paramdumpmode=yes savefamilyplots=yes savedatainseparatedir=yes \
	// wfseparation=yes
{

	// Start of sensible_nodes_sweep (sweep) analysis
	// with paramset
	// rram_sweep sweep paramset=r0_paramset {
	// no paramset
	// rram_sweep sweep param=p_level start=0 stop=p_total_levels step=200{
	// rram_sweep sweep param=p_tx_p_l start=40n stop=1.5u dec=5{
		// Start of reliability_framework_tran (tran) analysis
		reliability_framework_tran tran save=selected stop=p_sim_time
			+ method=gear2only annotate=no maxiters=5
			// + maxstep=p_max_step
			// + paramset=psettiming

		// export in p_sim_time
		export r_read=oceanEval("value(getData(\"rram_0.mem_0:rram_r_read\") 130n)")
		export g_ini=oceanEval("value(getData(\"rram_0.mem_0:rram_g\") 0n)")
		export g_end=oceanEval("value(getData(\"rram_0.mem_0:rram_g\") 130n)")
	// }

}// End of reliability_montecarlo (montecarlo ) analysis

mcOptions options genmcdep=yes

// Old options (TVLSI)
// simulation options
// simulatorOptions options temp=mT0Celsius genmcdep=yes
// + tnom=27 scale=1.0 gmin=1e-12 rforce=1 maxnotes=5 maxwarns=5 digits=5 cols=80 pivrel=1e-3
// + reltol=1e-8 vabstol=1e-9 iabstol=1e-11
// + reltol=1e-9 vabstol=1e-10 iabstol=1e-12

// New options
simulatorOptions options temp=p_temp tnom=27 scale=1.0 gmin=1e-12 rforce=1 maxnotes=5 maxwarns=5 digits=5 cols=80
		// + reltol=1e-8 vabstol=1e-9 iabstol=1e-11
		// + pivrel=1e-3 reltol=1e-10 vabstol=1e-10 iabstol=1e-13 // used for characterization
		// + pivrel=1e-3 reltol=1e-10 vabstol=1e-10 iabstol=1e-13

saveOptions options save=selected saveahdlvars=selected

// save statements
save n_write
save n_gate

save rram_0.mem_0:rram_r_read
save rram_0.mem_0:rram_g
