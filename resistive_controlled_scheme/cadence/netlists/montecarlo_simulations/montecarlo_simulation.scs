simulator lang=spectre

// simulation
parameters fw_firstrun=1 fw_seed=12345 fw_numruns=1000

// Variability is modeled using gamma0 parameter, according to
// Chen, P., & Yu, S. (2015). Compact Modeling of RRAM Devices and Its Applications in 1T1R and 1S1R Array Design.
// IEEE Transactions on Electron Devices, 62(12), 4022–4028. https://doi.org/10.1109/TED.2015.2492421
// Also, a variability in the initial stage p_rram_gap_ini_0 is considered

// memristor intra/inter device variability
// load resistance Variability
// memristor initial state variability
// CMOS variability by pdk
statistics{
	process{
		vary p_rram_gap_ini_0b dist=gauss std=0.5 percent=yes
		vary p_gamma0 dist=gauss std=0.05 percent=yes
		vary p_r0 dist=gauss std=2 percent=yes
		vary p_rram_seed dist=gauss std=500 percent=yes
	}
}

// Start of reliability_montecarlo (montecarlo) analysis
reliability_montecarlo montecarlo variations=process donominal=yes
	+ savefamilyplots=no  //set to yes if you want to save the transients
	+ firstrun=fw_firstrun seed=fw_seed numruns=fw_numruns
	+ scalarfile="../monteCarlo/mc_data"  //exported data file
	+ paramfile="../monteCarlo/mc_param"
	// saveprocessparams=yes \
	// processparamfile="../monteCarlo/processParam" \
	// processscalarfile="../monteCarlo/processData" savemismatchparams=yes
{

	// Start of sensible_nodes_sweep (sweep) analysis
	rram_sweep sweep param=p_level start=0 stop=p_total_levels step=1
	{
	// rram_sweep sweep param=p_tx_p_l start=40n stop=1.5u dec=5{
		// Start of reliability_framework_tran (tran) analysis
		reliability_framework_tran tran save=selected stop=p_sim_time
			+ method=gear2only annotate=no maxiters=5
			// + maxstep=p_max_step
			// + paramset=psettiming

		// export in p_sim_time

		// Perform file handle setup
		export r_read=oceanEval("value(getData(\"rram_0.mem_0:rram_r_read\") 130n)")
		// export g_ini=oceanEval("value(getData(\"rram_0.mem_0:rram_g\") 0n)")
		// export g_end=oceanEval("value(getData(\"rram_0.mem_0:rram_g\") 130n)")
	}

}// End of reliability_montecarlo (montecarlo ) analysis

mcOptions options genmcdep=yes

// New options
simulatorOptions options temp=p_temp tnom=27 scale=1.0 gmin=1e-12 rforce=1 maxnotes=5 maxwarns=5 digits=5 cols=80

	////////////////////////////////////////////////
	// Additional convergence options,  if needed //
	////////////////////////////////////////////////
		// + reltol=1e-9 vabstol=1e-10 iabstol=1e-12
		// + reltol=1e-8 vabstol=1e-9 iabstol=1e-11
		// + pivrel=1e-3 reltol=1e-10 vabstol=1e-10 iabstol=1e-13 // used for characterization
		// + pivrel=1e-3 reltol=1e-10 vabstol=1e-10 iabstol=1e-13

/////////////////
//Save options //
/////////////////
saveOptions options save=selected saveahdlvars=selected

////////////////////
//Save statements //
////////////////////

save rram_0.mem_0:rram_r_read
save rram_0.mem_0:rram_g
