simulator lang=spectre

characterization_tran tran save=selected stop=p_sim_time
		+ method=gear2only annotate=no maxiters=5
		+ maxstep=10p

// New options
simulatorOptions options temp=p_temp tnom=27 scale=1.0 gmin=1e-12 rforce=1 maxnotes=5 maxwarns=5 digits=5 cols=80
		+ reltol=1e-8 vabstol=1e-10 iabstol=1e-11
		// + pivrel=1e-3 reltol=1e-10 vabstol=1e-10 iabstol=1e-13 // used for characterization
		// + pivrel=1e-3 reltol=1e-10 vabstol=1e-10 iabstol=1e-13

saveOptions options save=selected saveahdlvars=selected

// save statements
save n_write
save n_gate

//////////////////
// Parasitics
//////////////////
// save rram_0.tx_src
// save rram_0.tx_drain
// save rram_0.mid1
// save rram_0.mid2

//////////////////
// rram 0
//////////////////
save rram_0.mem_0:gap_ddt
save rram_0.mem_0:rram_g
// save rram_0.mem_0:rram_temperature
save rram_0.mem_0:rram_v
save rram_0.mem_0:rram_i
save rram_0.mem_0:rram_r
save rram_0.mem_0:rram_r_read

save rram_0.mem_0:rram_r_read
