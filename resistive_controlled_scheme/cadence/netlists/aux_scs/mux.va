`include "constants.vams"
`include "disciplines.vams"

module mux(v_in, v_out, v_sel);

	output v_out;
	electrical v_out;

	input [31:0] v_in;
	input v_sel;
	electrical [31:0] v_in;
	electrical v_sel;

	integer select;
	real in;

	analog begin

		select = V(v_sel);
		case (select)
			0:        in=V(v_in[0]);
			1:        in=V(v_in[1]);
			2:        in=V(v_in[2]);
			3:        in=V(v_in[3]);
			4:        in=V(v_in[4]);
			5:        in=V(v_in[5]);
			6:        in=V(v_in[6]);
			7:        in=V(v_in[7]);
			8:        in=V(v_in[8]);
			9:        in=V(v_in[9]);
			10:        in=V(v_in[10]);
			11:        in=V(v_in[11]);
			12:        in=V(v_in[12]);
			13:        in=V(v_in[13]);
			14:        in=V(v_in[14]);
			15:        in=V(v_in[15]);
			16:        in=V(v_in[16]);
			17:        in=V(v_in[17]);
			18:        in=V(v_in[18]);
			19:        in=V(v_in[19]);
			20:        in=V(v_in[20]);
			21:        in=V(v_in[21]);
			22:        in=V(v_in[22]);
			23:        in=V(v_in[23]);
			24:        in=V(v_in[24]);
			25:        in=V(v_in[25]);
			26:        in=V(v_in[26]);
			27:        in=V(v_in[27]);
			28:        in=V(v_in[28]);
			29:        in=V(v_in[29]);
			30:        in=V(v_in[30]);
			31:        in=V(v_in[31]);
			default:  in=0;
		endcase
		V(v_out) <+ in;

		end
	endmodule
