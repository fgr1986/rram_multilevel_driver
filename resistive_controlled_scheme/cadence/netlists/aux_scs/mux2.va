`include "constants.vams"
`include "disciplines.vams"

// module mux2(v_in1, v_in2,v_out, v_sel);
//
//   output v_out;
//   electrical v_out;
//   input v_in1, v_in2
//   input v_sel;
//   electrical v_in1, v_in2, v_sel ;
//
//   parameter real vtrans = 0.5;
//   parameter real vlow = 0;
//   parameter real vhigh = 1 ;
//   parameter real trise = 1p;
//   parameter real tfall= 1p;
//   parameter real tdel= 1p;
//
//   real in;
//   analog begin
//     in = (V(v_sel) > vtrans) ? V(v_in2): V(v_in1);
//     V(v_out) <+ transition (vhigh*in + vlow*!in , tdel, trise, tfall);
//     // V(v_out) <+ in;
//   end
//
// endmodule

module mux2(v_in, v_out, v_sel);

  output v_out;
  electrical v_out;

  input [1:0] v_in;
  input v_sel;
  electrical [1:0] v_in;
  electrical v_sel ;

  // parameter integer sel = 0;
  integer select;

  real in;

  analog begin
    select = V(v_sel);

    case (select)
      0:        in=V(v_in[0]);
      1:        in=V(v_in[1]);
      default:  in=0;
    endcase

    V(v_out) <+ in;

  end

endmodule

// module mux2(v_in_0, v_in_1, v_out, v_sel);
//
//   output v_out;
//   electrical v_out;
//
//   input v_in_0;
//   input v_in_1;
//   input v_sel;
//   electrical v_in_0, v_in_1;
//   electrical v_sel ;
//
//   // parameter integer sel = 0;
//   integer select;
//
//   real in;
//
//   analog begin
//     select = V(v_sel);
//
//     case (select)
//       0:        in=V(v_in_0);
//       1:        in=V(v_in_1);
//       default:  in=0;
//     endcase
//
//     V(v_out) <+ in;
//
//   end
//
// endmodule
