simulator lang=spectre

ahdl_include "analog_mux.va"

//////////////////////////////////
// Resistive loads and analog_mux cell //
// v0.1 24/10/2017              //
//////////////////////////////////

subckt resistive_loads (to_rram)

	parameters mux_level=0
	r_1023 (n_1023 n_1022) resistor r=0.25k
	r_1022 (n_1022 n_1021) resistor r=0.25k
	r_1021 (n_1021 n_1020) resistor r=0.25k
	r_1020 (n_1020 n_1019) resistor r=0.25k
	r_1019 (n_1019 n_1018) resistor r=0.25k
	r_1018 (n_1018 n_1017) resistor r=0.25k
	r_1017 (n_1017 n_1016) resistor r=0.25k
	r_1016 (n_1016 n_1015) resistor r=0.25k
	r_1015 (n_1015 n_1014) resistor r=0.25k
	r_1014 (n_1014 n_1013) resistor r=0.25k
	r_1013 (n_1013 n_1012) resistor r=0.25k
	r_1012 (n_1012 n_1011) resistor r=0.25k
	r_1011 (n_1011 n_1010) resistor r=0.25k
	r_1010 (n_1010 n_1009) resistor r=0.25k
	r_1009 (n_1009 n_1008) resistor r=0.25k
	r_1008 (n_1008 n_1007) resistor r=0.25k
	r_1007 (n_1007 n_1006) resistor r=0.25k
	r_1006 (n_1006 n_1005) resistor r=0.25k
	r_1005 (n_1005 n_1004) resistor r=0.25k
	r_1004 (n_1004 n_1003) resistor r=0.25k
	r_1003 (n_1003 n_1002) resistor r=0.25k
	r_1002 (n_1002 n_1001) resistor r=0.25k
	r_1001 (n_1001 n_1000) resistor r=0.25k
	r_1000 (n_1000 n_999) resistor r=0.25k
	r_999 (n_999 n_998) resistor r=0.25k
	r_998 (n_998 n_997) resistor r=0.25k
	r_997 (n_997 n_996) resistor r=0.25k
	r_996 (n_996 n_995) resistor r=0.25k
	r_995 (n_995 n_994) resistor r=0.25k
	r_994 (n_994 n_993) resistor r=0.25k
	r_993 (n_993 n_992) resistor r=0.25k
	r_992 (n_992 n_991) resistor r=0.25k
	r_991 (n_991 n_990) resistor r=0.25k
	r_990 (n_990 n_989) resistor r=0.25k
	r_989 (n_989 n_988) resistor r=0.25k
	r_988 (n_988 n_987) resistor r=0.25k
	r_987 (n_987 n_986) resistor r=0.25k
	r_986 (n_986 n_985) resistor r=0.25k
	r_985 (n_985 n_984) resistor r=0.25k
	r_984 (n_984 n_983) resistor r=0.25k
	r_983 (n_983 n_982) resistor r=0.25k
	r_982 (n_982 n_981) resistor r=0.25k
	r_981 (n_981 n_980) resistor r=0.25k
	r_980 (n_980 n_979) resistor r=0.25k
	r_979 (n_979 n_978) resistor r=0.25k
	r_978 (n_978 n_977) resistor r=0.25k
	r_977 (n_977 n_976) resistor r=0.25k
	r_976 (n_976 n_975) resistor r=0.25k
	r_975 (n_975 n_974) resistor r=0.25k
	r_974 (n_974 n_973) resistor r=0.25k
	r_973 (n_973 n_972) resistor r=0.25k
	r_972 (n_972 n_971) resistor r=0.25k
	r_971 (n_971 n_970) resistor r=0.25k
	r_970 (n_970 n_969) resistor r=0.25k
	r_969 (n_969 n_968) resistor r=0.25k
	r_968 (n_968 n_967) resistor r=0.25k
	r_967 (n_967 n_966) resistor r=0.25k
	r_966 (n_966 n_965) resistor r=0.25k
	r_965 (n_965 n_964) resistor r=0.25k
	r_964 (n_964 n_963) resistor r=0.25k
	r_963 (n_963 n_962) resistor r=0.25k
	r_962 (n_962 n_961) resistor r=0.25k
	r_961 (n_961 n_960) resistor r=0.25k
	r_960 (n_960 n_959) resistor r=0.25k
	r_959 (n_959 n_958) resistor r=0.25k
	r_958 (n_958 n_957) resistor r=0.25k
	r_957 (n_957 n_956) resistor r=0.25k
	r_956 (n_956 n_955) resistor r=0.25k
	r_955 (n_955 n_954) resistor r=0.25k
	r_954 (n_954 n_953) resistor r=0.25k
	r_953 (n_953 n_952) resistor r=0.25k
	r_952 (n_952 n_951) resistor r=0.25k
	r_951 (n_951 n_950) resistor r=0.25k
	r_950 (n_950 n_949) resistor r=0.25k
	r_949 (n_949 n_948) resistor r=0.25k
	r_948 (n_948 n_947) resistor r=0.25k
	r_947 (n_947 n_946) resistor r=0.25k
	r_946 (n_946 n_945) resistor r=0.25k
	r_945 (n_945 n_944) resistor r=0.25k
	r_944 (n_944 n_943) resistor r=0.25k
	r_943 (n_943 n_942) resistor r=0.25k
	r_942 (n_942 n_941) resistor r=0.25k
	r_941 (n_941 n_940) resistor r=0.25k
	r_940 (n_940 n_939) resistor r=0.25k
	r_939 (n_939 n_938) resistor r=0.25k
	r_938 (n_938 n_937) resistor r=0.25k
	r_937 (n_937 n_936) resistor r=0.25k
	r_936 (n_936 n_935) resistor r=0.25k
	r_935 (n_935 n_934) resistor r=0.25k
	r_934 (n_934 n_933) resistor r=0.25k
	r_933 (n_933 n_932) resistor r=0.25k
	r_932 (n_932 n_931) resistor r=0.25k
	r_931 (n_931 n_930) resistor r=0.25k
	r_930 (n_930 n_929) resistor r=0.25k
	r_929 (n_929 n_928) resistor r=0.25k
	r_928 (n_928 n_927) resistor r=0.25k
	r_927 (n_927 n_926) resistor r=0.25k
	r_926 (n_926 n_925) resistor r=0.25k
	r_925 (n_925 n_924) resistor r=0.25k
	r_924 (n_924 n_923) resistor r=0.25k
	r_923 (n_923 n_922) resistor r=0.25k
	r_922 (n_922 n_921) resistor r=0.25k
	r_921 (n_921 n_920) resistor r=0.25k
	r_920 (n_920 n_919) resistor r=0.25k
	r_919 (n_919 n_918) resistor r=0.25k
	r_918 (n_918 n_917) resistor r=0.25k
	r_917 (n_917 n_916) resistor r=0.25k
	r_916 (n_916 n_915) resistor r=0.25k
	r_915 (n_915 n_914) resistor r=0.25k
	r_914 (n_914 n_913) resistor r=0.25k
	r_913 (n_913 n_912) resistor r=0.25k
	r_912 (n_912 n_911) resistor r=0.25k
	r_911 (n_911 n_910) resistor r=0.25k
	r_910 (n_910 n_909) resistor r=0.25k
	r_909 (n_909 n_908) resistor r=0.25k
	r_908 (n_908 n_907) resistor r=0.25k
	r_907 (n_907 n_906) resistor r=0.25k
	r_906 (n_906 n_905) resistor r=0.25k
	r_905 (n_905 n_904) resistor r=0.25k
	r_904 (n_904 n_903) resistor r=0.25k
	r_903 (n_903 n_902) resistor r=0.25k
	r_902 (n_902 n_901) resistor r=0.25k
	r_901 (n_901 n_900) resistor r=0.25k
	r_900 (n_900 n_899) resistor r=0.25k
	r_899 (n_899 n_898) resistor r=0.25k
	r_898 (n_898 n_897) resistor r=0.25k
	r_897 (n_897 n_896) resistor r=0.25k
	r_896 (n_896 n_895) resistor r=0.25k
	r_895 (n_895 n_894) resistor r=0.25k
	r_894 (n_894 n_893) resistor r=0.25k
	r_893 (n_893 n_892) resistor r=0.25k
	r_892 (n_892 n_891) resistor r=0.25k
	r_891 (n_891 n_890) resistor r=0.25k
	r_890 (n_890 n_889) resistor r=0.25k
	r_889 (n_889 n_888) resistor r=0.25k
	r_888 (n_888 n_887) resistor r=0.25k
	r_887 (n_887 n_886) resistor r=0.25k
	r_886 (n_886 n_885) resistor r=0.25k
	r_885 (n_885 n_884) resistor r=0.25k
	r_884 (n_884 n_883) resistor r=0.25k
	r_883 (n_883 n_882) resistor r=0.25k
	r_882 (n_882 n_881) resistor r=0.25k
	r_881 (n_881 n_880) resistor r=0.25k
	r_880 (n_880 n_879) resistor r=0.25k
	r_879 (n_879 n_878) resistor r=0.25k
	r_878 (n_878 n_877) resistor r=0.25k
	r_877 (n_877 n_876) resistor r=0.25k
	r_876 (n_876 n_875) resistor r=0.25k
	r_875 (n_875 n_874) resistor r=0.25k
	r_874 (n_874 n_873) resistor r=0.25k
	r_873 (n_873 n_872) resistor r=0.25k
	r_872 (n_872 n_871) resistor r=0.25k
	r_871 (n_871 n_870) resistor r=0.25k
	r_870 (n_870 n_869) resistor r=0.25k
	r_869 (n_869 n_868) resistor r=0.25k
	r_868 (n_868 n_867) resistor r=0.25k
	r_867 (n_867 n_866) resistor r=0.25k
	r_866 (n_866 n_865) resistor r=0.25k
	r_865 (n_865 n_864) resistor r=0.25k
	r_864 (n_864 n_863) resistor r=0.25k
	r_863 (n_863 n_862) resistor r=0.25k
	r_862 (n_862 n_861) resistor r=0.25k
	r_861 (n_861 n_860) resistor r=0.25k
	r_860 (n_860 n_859) resistor r=0.25k
	r_859 (n_859 n_858) resistor r=0.25k
	r_858 (n_858 n_857) resistor r=0.25k
	r_857 (n_857 n_856) resistor r=0.25k
	r_856 (n_856 n_855) resistor r=0.25k
	r_855 (n_855 n_854) resistor r=0.25k
	r_854 (n_854 n_853) resistor r=0.25k
	r_853 (n_853 n_852) resistor r=0.25k
	r_852 (n_852 n_851) resistor r=0.25k
	r_851 (n_851 n_850) resistor r=0.25k
	r_850 (n_850 n_849) resistor r=0.25k
	r_849 (n_849 n_848) resistor r=0.25k
	r_848 (n_848 n_847) resistor r=0.25k
	r_847 (n_847 n_846) resistor r=0.25k
	r_846 (n_846 n_845) resistor r=0.25k
	r_845 (n_845 n_844) resistor r=0.25k
	r_844 (n_844 n_843) resistor r=0.25k
	r_843 (n_843 n_842) resistor r=0.25k
	r_842 (n_842 n_841) resistor r=0.25k
	r_841 (n_841 n_840) resistor r=0.25k
	r_840 (n_840 n_839) resistor r=0.25k
	r_839 (n_839 n_838) resistor r=0.25k
	r_838 (n_838 n_837) resistor r=0.25k
	r_837 (n_837 n_836) resistor r=0.25k
	r_836 (n_836 n_835) resistor r=0.25k
	r_835 (n_835 n_834) resistor r=0.25k
	r_834 (n_834 n_833) resistor r=0.25k
	r_833 (n_833 n_832) resistor r=0.25k
	r_832 (n_832 n_831) resistor r=0.25k
	r_831 (n_831 n_830) resistor r=0.25k
	r_830 (n_830 n_829) resistor r=0.25k
	r_829 (n_829 n_828) resistor r=0.25k
	r_828 (n_828 n_827) resistor r=0.25k
	r_827 (n_827 n_826) resistor r=0.25k
	r_826 (n_826 n_825) resistor r=0.25k
	r_825 (n_825 n_824) resistor r=0.25k
	r_824 (n_824 n_823) resistor r=0.25k
	r_823 (n_823 n_822) resistor r=0.25k
	r_822 (n_822 n_821) resistor r=0.25k
	r_821 (n_821 n_820) resistor r=0.25k
	r_820 (n_820 n_819) resistor r=0.25k
	r_819 (n_819 n_818) resistor r=0.25k
	r_818 (n_818 n_817) resistor r=0.25k
	r_817 (n_817 n_816) resistor r=0.25k
	r_816 (n_816 n_815) resistor r=0.25k
	r_815 (n_815 n_814) resistor r=0.25k
	r_814 (n_814 n_813) resistor r=0.25k
	r_813 (n_813 n_812) resistor r=0.25k
	r_812 (n_812 n_811) resistor r=0.25k
	r_811 (n_811 n_810) resistor r=0.25k
	r_810 (n_810 n_809) resistor r=0.25k
	r_809 (n_809 n_808) resistor r=0.25k
	r_808 (n_808 n_807) resistor r=0.25k
	r_807 (n_807 n_806) resistor r=0.25k
	r_806 (n_806 n_805) resistor r=0.25k
	r_805 (n_805 n_804) resistor r=0.25k
	r_804 (n_804 n_803) resistor r=0.25k
	r_803 (n_803 n_802) resistor r=0.25k
	r_802 (n_802 n_801) resistor r=0.25k
	r_801 (n_801 n_800) resistor r=0.25k
	r_800 (n_800 n_799) resistor r=0.25k
	r_799 (n_799 n_798) resistor r=0.25k
	r_798 (n_798 n_797) resistor r=0.25k
	r_797 (n_797 n_796) resistor r=0.25k
	r_796 (n_796 n_795) resistor r=0.25k
	r_795 (n_795 n_794) resistor r=0.25k
	r_794 (n_794 n_793) resistor r=0.25k
	r_793 (n_793 n_792) resistor r=0.25k
	r_792 (n_792 n_791) resistor r=0.25k
	r_791 (n_791 n_790) resistor r=0.25k
	r_790 (n_790 n_789) resistor r=0.25k
	r_789 (n_789 n_788) resistor r=0.25k
	r_788 (n_788 n_787) resistor r=0.25k
	r_787 (n_787 n_786) resistor r=0.25k
	r_786 (n_786 n_785) resistor r=0.25k
	r_785 (n_785 n_784) resistor r=0.25k
	r_784 (n_784 n_783) resistor r=0.25k
	r_783 (n_783 n_782) resistor r=0.25k
	r_782 (n_782 n_781) resistor r=0.25k
	r_781 (n_781 n_780) resistor r=0.25k
	r_780 (n_780 n_779) resistor r=0.25k
	r_779 (n_779 n_778) resistor r=0.25k
	r_778 (n_778 n_777) resistor r=0.25k
	r_777 (n_777 n_776) resistor r=0.25k
	r_776 (n_776 n_775) resistor r=0.25k
	r_775 (n_775 n_774) resistor r=0.25k
	r_774 (n_774 n_773) resistor r=0.25k
	r_773 (n_773 n_772) resistor r=0.25k
	r_772 (n_772 n_771) resistor r=0.25k
	r_771 (n_771 n_770) resistor r=0.25k
	r_770 (n_770 n_769) resistor r=0.25k
	r_769 (n_769 n_768) resistor r=0.25k
	r_768 (n_768 n_767) resistor r=0.25k
	r_767 (n_767 n_766) resistor r=0.25k
	r_766 (n_766 n_765) resistor r=0.25k
	r_765 (n_765 n_764) resistor r=0.25k
	r_764 (n_764 n_763) resistor r=0.25k
	r_763 (n_763 n_762) resistor r=0.25k
	r_762 (n_762 n_761) resistor r=0.25k
	r_761 (n_761 n_760) resistor r=0.25k
	r_760 (n_760 n_759) resistor r=0.25k
	r_759 (n_759 n_758) resistor r=0.25k
	r_758 (n_758 n_757) resistor r=0.25k
	r_757 (n_757 n_756) resistor r=0.25k
	r_756 (n_756 n_755) resistor r=0.25k
	r_755 (n_755 n_754) resistor r=0.25k
	r_754 (n_754 n_753) resistor r=0.25k
	r_753 (n_753 n_752) resistor r=0.25k
	r_752 (n_752 n_751) resistor r=0.25k
	r_751 (n_751 n_750) resistor r=0.25k
	r_750 (n_750 n_749) resistor r=0.25k
	r_749 (n_749 n_748) resistor r=0.25k
	r_748 (n_748 n_747) resistor r=0.25k
	r_747 (n_747 n_746) resistor r=0.25k
	r_746 (n_746 n_745) resistor r=0.25k
	r_745 (n_745 n_744) resistor r=0.25k
	r_744 (n_744 n_743) resistor r=0.25k
	r_743 (n_743 n_742) resistor r=0.25k
	r_742 (n_742 n_741) resistor r=0.25k
	r_741 (n_741 n_740) resistor r=0.25k
	r_740 (n_740 n_739) resistor r=0.25k
	r_739 (n_739 n_738) resistor r=0.25k
	r_738 (n_738 n_737) resistor r=0.25k
	r_737 (n_737 n_736) resistor r=0.25k
	r_736 (n_736 n_735) resistor r=0.25k
	r_735 (n_735 n_734) resistor r=0.25k
	r_734 (n_734 n_733) resistor r=0.25k
	r_733 (n_733 n_732) resistor r=0.25k
	r_732 (n_732 n_731) resistor r=0.25k
	r_731 (n_731 n_730) resistor r=0.25k
	r_730 (n_730 n_729) resistor r=0.25k
	r_729 (n_729 n_728) resistor r=0.25k
	r_728 (n_728 n_727) resistor r=0.25k
	r_727 (n_727 n_726) resistor r=0.25k
	r_726 (n_726 n_725) resistor r=0.25k
	r_725 (n_725 n_724) resistor r=0.25k
	r_724 (n_724 n_723) resistor r=0.25k
	r_723 (n_723 n_722) resistor r=0.25k
	r_722 (n_722 n_721) resistor r=0.25k
	r_721 (n_721 n_720) resistor r=0.25k
	r_720 (n_720 n_719) resistor r=0.25k
	r_719 (n_719 n_718) resistor r=0.25k
	r_718 (n_718 n_717) resistor r=0.25k
	r_717 (n_717 n_716) resistor r=0.25k
	r_716 (n_716 n_715) resistor r=0.25k
	r_715 (n_715 n_714) resistor r=0.25k
	r_714 (n_714 n_713) resistor r=0.25k
	r_713 (n_713 n_712) resistor r=0.25k
	r_712 (n_712 n_711) resistor r=0.25k
	r_711 (n_711 n_710) resistor r=0.25k
	r_710 (n_710 n_709) resistor r=0.25k
	r_709 (n_709 n_708) resistor r=0.25k
	r_708 (n_708 n_707) resistor r=0.25k
	r_707 (n_707 n_706) resistor r=0.25k
	r_706 (n_706 n_705) resistor r=0.25k
	r_705 (n_705 n_704) resistor r=0.25k
	r_704 (n_704 n_703) resistor r=0.25k
	r_703 (n_703 n_702) resistor r=0.25k
	r_702 (n_702 n_701) resistor r=0.25k
	r_701 (n_701 n_700) resistor r=0.25k
	r_700 (n_700 n_699) resistor r=0.25k
	r_699 (n_699 n_698) resistor r=0.25k
	r_698 (n_698 n_697) resistor r=0.25k
	r_697 (n_697 n_696) resistor r=0.25k
	r_696 (n_696 n_695) resistor r=0.25k
	r_695 (n_695 n_694) resistor r=0.25k
	r_694 (n_694 n_693) resistor r=0.25k
	r_693 (n_693 n_692) resistor r=0.25k
	r_692 (n_692 n_691) resistor r=0.25k
	r_691 (n_691 n_690) resistor r=0.25k
	r_690 (n_690 n_689) resistor r=0.25k
	r_689 (n_689 n_688) resistor r=0.25k
	r_688 (n_688 n_687) resistor r=0.25k
	r_687 (n_687 n_686) resistor r=0.25k
	r_686 (n_686 n_685) resistor r=0.25k
	r_685 (n_685 n_684) resistor r=0.25k
	r_684 (n_684 n_683) resistor r=0.25k
	r_683 (n_683 n_682) resistor r=0.25k
	r_682 (n_682 n_681) resistor r=0.25k
	r_681 (n_681 n_680) resistor r=0.25k
	r_680 (n_680 n_679) resistor r=0.25k
	r_679 (n_679 n_678) resistor r=0.25k
	r_678 (n_678 n_677) resistor r=0.25k
	r_677 (n_677 n_676) resistor r=0.25k
	r_676 (n_676 n_675) resistor r=0.25k
	r_675 (n_675 n_674) resistor r=0.25k
	r_674 (n_674 n_673) resistor r=0.25k
	r_673 (n_673 n_672) resistor r=0.25k
	r_672 (n_672 n_671) resistor r=0.25k
	r_671 (n_671 n_670) resistor r=0.25k
	r_670 (n_670 n_669) resistor r=0.25k
	r_669 (n_669 n_668) resistor r=0.25k
	r_668 (n_668 n_667) resistor r=0.25k
	r_667 (n_667 n_666) resistor r=0.25k
	r_666 (n_666 n_665) resistor r=0.25k
	r_665 (n_665 n_664) resistor r=0.25k
	r_664 (n_664 n_663) resistor r=0.25k
	r_663 (n_663 n_662) resistor r=0.25k
	r_662 (n_662 n_661) resistor r=0.25k
	r_661 (n_661 n_660) resistor r=0.25k
	r_660 (n_660 n_659) resistor r=0.25k
	r_659 (n_659 n_658) resistor r=0.25k
	r_658 (n_658 n_657) resistor r=0.25k
	r_657 (n_657 n_656) resistor r=0.25k
	r_656 (n_656 n_655) resistor r=0.25k
	r_655 (n_655 n_654) resistor r=0.25k
	r_654 (n_654 n_653) resistor r=0.25k
	r_653 (n_653 n_652) resistor r=0.25k
	r_652 (n_652 n_651) resistor r=0.25k
	r_651 (n_651 n_650) resistor r=0.25k
	r_650 (n_650 n_649) resistor r=0.25k
	r_649 (n_649 n_648) resistor r=0.25k
	r_648 (n_648 n_647) resistor r=0.25k
	r_647 (n_647 n_646) resistor r=0.25k
	r_646 (n_646 n_645) resistor r=0.25k
	r_645 (n_645 n_644) resistor r=0.25k
	r_644 (n_644 n_643) resistor r=0.25k
	r_643 (n_643 n_642) resistor r=0.25k
	r_642 (n_642 n_641) resistor r=0.25k
	r_641 (n_641 n_640) resistor r=0.25k
	r_640 (n_640 n_639) resistor r=0.25k
	r_639 (n_639 n_638) resistor r=0.25k
	r_638 (n_638 n_637) resistor r=0.25k
	r_637 (n_637 n_636) resistor r=0.25k
	r_636 (n_636 n_635) resistor r=0.25k
	r_635 (n_635 n_634) resistor r=0.25k
	r_634 (n_634 n_633) resistor r=0.25k
	r_633 (n_633 n_632) resistor r=0.25k
	r_632 (n_632 n_631) resistor r=0.25k
	r_631 (n_631 n_630) resistor r=0.25k
	r_630 (n_630 n_629) resistor r=0.25k
	r_629 (n_629 n_628) resistor r=0.25k
	r_628 (n_628 n_627) resistor r=0.25k
	r_627 (n_627 n_626) resistor r=0.25k
	r_626 (n_626 n_625) resistor r=0.25k
	r_625 (n_625 n_624) resistor r=0.25k
	r_624 (n_624 n_623) resistor r=0.25k
	r_623 (n_623 n_622) resistor r=0.25k
	r_622 (n_622 n_621) resistor r=0.25k
	r_621 (n_621 n_620) resistor r=0.25k
	r_620 (n_620 n_619) resistor r=0.25k
	r_619 (n_619 n_618) resistor r=0.25k
	r_618 (n_618 n_617) resistor r=0.25k
	r_617 (n_617 n_616) resistor r=0.25k
	r_616 (n_616 n_615) resistor r=0.25k
	r_615 (n_615 n_614) resistor r=0.25k
	r_614 (n_614 n_613) resistor r=0.25k
	r_613 (n_613 n_612) resistor r=0.25k
	r_612 (n_612 n_611) resistor r=0.25k
	r_611 (n_611 n_610) resistor r=0.25k
	r_610 (n_610 n_609) resistor r=0.25k
	r_609 (n_609 n_608) resistor r=0.25k
	r_608 (n_608 n_607) resistor r=0.25k
	r_607 (n_607 n_606) resistor r=0.25k
	r_606 (n_606 n_605) resistor r=0.25k
	r_605 (n_605 n_604) resistor r=0.25k
	r_604 (n_604 n_603) resistor r=0.25k
	r_603 (n_603 n_602) resistor r=0.25k
	r_602 (n_602 n_601) resistor r=0.25k
	r_601 (n_601 n_600) resistor r=0.25k
	r_600 (n_600 n_599) resistor r=0.25k
	r_599 (n_599 n_598) resistor r=0.25k
	r_598 (n_598 n_597) resistor r=0.25k
	r_597 (n_597 n_596) resistor r=0.25k
	r_596 (n_596 n_595) resistor r=0.25k
	r_595 (n_595 n_594) resistor r=0.25k
	r_594 (n_594 n_593) resistor r=0.25k
	r_593 (n_593 n_592) resistor r=0.25k
	r_592 (n_592 n_591) resistor r=0.25k
	r_591 (n_591 n_590) resistor r=0.25k
	r_590 (n_590 n_589) resistor r=0.25k
	r_589 (n_589 n_588) resistor r=0.25k
	r_588 (n_588 n_587) resistor r=0.25k
	r_587 (n_587 n_586) resistor r=0.25k
	r_586 (n_586 n_585) resistor r=0.25k
	r_585 (n_585 n_584) resistor r=0.25k
	r_584 (n_584 n_583) resistor r=0.25k
	r_583 (n_583 n_582) resistor r=0.25k
	r_582 (n_582 n_581) resistor r=0.25k
	r_581 (n_581 n_580) resistor r=0.25k
	r_580 (n_580 n_579) resistor r=0.25k
	r_579 (n_579 n_578) resistor r=0.25k
	r_578 (n_578 n_577) resistor r=0.25k
	r_577 (n_577 n_576) resistor r=0.25k
	r_576 (n_576 n_575) resistor r=0.25k
	r_575 (n_575 n_574) resistor r=0.25k
	r_574 (n_574 n_573) resistor r=0.25k
	r_573 (n_573 n_572) resistor r=0.25k
	r_572 (n_572 n_571) resistor r=0.25k
	r_571 (n_571 n_570) resistor r=0.25k
	r_570 (n_570 n_569) resistor r=0.25k
	r_569 (n_569 n_568) resistor r=0.25k
	r_568 (n_568 n_567) resistor r=0.25k
	r_567 (n_567 n_566) resistor r=0.25k
	r_566 (n_566 n_565) resistor r=0.25k
	r_565 (n_565 n_564) resistor r=0.25k
	r_564 (n_564 n_563) resistor r=0.25k
	r_563 (n_563 n_562) resistor r=0.25k
	r_562 (n_562 n_561) resistor r=0.25k
	r_561 (n_561 n_560) resistor r=0.25k
	r_560 (n_560 n_559) resistor r=0.25k
	r_559 (n_559 n_558) resistor r=0.25k
	r_558 (n_558 n_557) resistor r=0.25k
	r_557 (n_557 n_556) resistor r=0.25k
	r_556 (n_556 n_555) resistor r=0.25k
	r_555 (n_555 n_554) resistor r=0.25k
	r_554 (n_554 n_553) resistor r=0.25k
	r_553 (n_553 n_552) resistor r=0.25k
	r_552 (n_552 n_551) resistor r=0.25k
	r_551 (n_551 n_550) resistor r=0.25k
	r_550 (n_550 n_549) resistor r=0.25k
	r_549 (n_549 n_548) resistor r=0.25k
	r_548 (n_548 n_547) resistor r=0.25k
	r_547 (n_547 n_546) resistor r=0.25k
	r_546 (n_546 n_545) resistor r=0.25k
	r_545 (n_545 n_544) resistor r=0.25k
	r_544 (n_544 n_543) resistor r=0.25k
	r_543 (n_543 n_542) resistor r=0.25k
	r_542 (n_542 n_541) resistor r=0.25k
	r_541 (n_541 n_540) resistor r=0.25k
	r_540 (n_540 n_539) resistor r=0.25k
	r_539 (n_539 n_538) resistor r=0.25k
	r_538 (n_538 n_537) resistor r=0.25k
	r_537 (n_537 n_536) resistor r=0.25k
	r_536 (n_536 n_535) resistor r=0.25k
	r_535 (n_535 n_534) resistor r=0.25k
	r_534 (n_534 n_533) resistor r=0.25k
	r_533 (n_533 n_532) resistor r=0.25k
	r_532 (n_532 n_531) resistor r=0.25k
	r_531 (n_531 n_530) resistor r=0.25k
	r_530 (n_530 n_529) resistor r=0.25k
	r_529 (n_529 n_528) resistor r=0.25k
	r_528 (n_528 n_527) resistor r=0.25k
	r_527 (n_527 n_526) resistor r=0.25k
	r_526 (n_526 n_525) resistor r=0.25k
	r_525 (n_525 n_524) resistor r=0.25k
	r_524 (n_524 n_523) resistor r=0.25k
	r_523 (n_523 n_522) resistor r=0.25k
	r_522 (n_522 n_521) resistor r=0.25k
	r_521 (n_521 n_520) resistor r=0.25k
	r_520 (n_520 n_519) resistor r=0.25k
	r_519 (n_519 n_518) resistor r=0.25k
	r_518 (n_518 n_517) resistor r=0.25k
	r_517 (n_517 n_516) resistor r=0.25k
	r_516 (n_516 n_515) resistor r=0.25k
	r_515 (n_515 n_514) resistor r=0.25k
	r_514 (n_514 n_513) resistor r=0.25k
	r_513 (n_513 n_512) resistor r=0.25k
	r_512 (n_512 n_511) resistor r=0.25k
	r_511 (n_511 n_510) resistor r=0.25k
	r_510 (n_510 n_509) resistor r=0.25k
	r_509 (n_509 n_508) resistor r=0.25k
	r_508 (n_508 n_507) resistor r=0.25k
	r_507 (n_507 n_506) resistor r=0.25k
	r_506 (n_506 n_505) resistor r=0.25k
	r_505 (n_505 n_504) resistor r=0.25k
	r_504 (n_504 n_503) resistor r=0.25k
	r_503 (n_503 n_502) resistor r=0.25k
	r_502 (n_502 n_501) resistor r=0.25k
	r_501 (n_501 n_500) resistor r=0.25k
	r_500 (n_500 n_499) resistor r=0.25k
	r_499 (n_499 n_498) resistor r=0.25k
	r_498 (n_498 n_497) resistor r=0.25k
	r_497 (n_497 n_496) resistor r=0.25k
	r_496 (n_496 n_495) resistor r=0.25k
	r_495 (n_495 n_494) resistor r=0.25k
	r_494 (n_494 n_493) resistor r=0.25k
	r_493 (n_493 n_492) resistor r=0.25k
	r_492 (n_492 n_491) resistor r=0.25k
	r_491 (n_491 n_490) resistor r=0.25k
	r_490 (n_490 n_489) resistor r=0.25k
	r_489 (n_489 n_488) resistor r=0.25k
	r_488 (n_488 n_487) resistor r=0.25k
	r_487 (n_487 n_486) resistor r=0.25k
	r_486 (n_486 n_485) resistor r=0.25k
	r_485 (n_485 n_484) resistor r=0.25k
	r_484 (n_484 n_483) resistor r=0.25k
	r_483 (n_483 n_482) resistor r=0.25k
	r_482 (n_482 n_481) resistor r=0.25k
	r_481 (n_481 n_480) resistor r=0.25k
	r_480 (n_480 n_479) resistor r=0.25k
	r_479 (n_479 n_478) resistor r=0.25k
	r_478 (n_478 n_477) resistor r=0.25k
	r_477 (n_477 n_476) resistor r=0.25k
	r_476 (n_476 n_475) resistor r=0.25k
	r_475 (n_475 n_474) resistor r=0.25k
	r_474 (n_474 n_473) resistor r=0.25k
	r_473 (n_473 n_472) resistor r=0.25k
	r_472 (n_472 n_471) resistor r=0.25k
	r_471 (n_471 n_470) resistor r=0.25k
	r_470 (n_470 n_469) resistor r=0.25k
	r_469 (n_469 n_468) resistor r=0.25k
	r_468 (n_468 n_467) resistor r=0.25k
	r_467 (n_467 n_466) resistor r=0.25k
	r_466 (n_466 n_465) resistor r=0.25k
	r_465 (n_465 n_464) resistor r=0.25k
	r_464 (n_464 n_463) resistor r=0.25k
	r_463 (n_463 n_462) resistor r=0.25k
	r_462 (n_462 n_461) resistor r=0.25k
	r_461 (n_461 n_460) resistor r=0.25k
	r_460 (n_460 n_459) resistor r=0.25k
	r_459 (n_459 n_458) resistor r=0.25k
	r_458 (n_458 n_457) resistor r=0.25k
	r_457 (n_457 n_456) resistor r=0.25k
	r_456 (n_456 n_455) resistor r=0.25k
	r_455 (n_455 n_454) resistor r=0.25k
	r_454 (n_454 n_453) resistor r=0.25k
	r_453 (n_453 n_452) resistor r=0.25k
	r_452 (n_452 n_451) resistor r=0.25k
	r_451 (n_451 n_450) resistor r=0.25k
	r_450 (n_450 n_449) resistor r=0.25k
	r_449 (n_449 n_448) resistor r=0.25k
	r_448 (n_448 n_447) resistor r=0.25k
	r_447 (n_447 n_446) resistor r=0.25k
	r_446 (n_446 n_445) resistor r=0.25k
	r_445 (n_445 n_444) resistor r=0.25k
	r_444 (n_444 n_443) resistor r=0.25k
	r_443 (n_443 n_442) resistor r=0.25k
	r_442 (n_442 n_441) resistor r=0.25k
	r_441 (n_441 n_440) resistor r=0.25k
	r_440 (n_440 n_439) resistor r=0.25k
	r_439 (n_439 n_438) resistor r=0.25k
	r_438 (n_438 n_437) resistor r=0.25k
	r_437 (n_437 n_436) resistor r=0.25k
	r_436 (n_436 n_435) resistor r=0.25k
	r_435 (n_435 n_434) resistor r=0.25k
	r_434 (n_434 n_433) resistor r=0.25k
	r_433 (n_433 n_432) resistor r=0.25k
	r_432 (n_432 n_431) resistor r=0.25k
	r_431 (n_431 n_430) resistor r=0.25k
	r_430 (n_430 n_429) resistor r=0.25k
	r_429 (n_429 n_428) resistor r=0.25k
	r_428 (n_428 n_427) resistor r=0.25k
	r_427 (n_427 n_426) resistor r=0.25k
	r_426 (n_426 n_425) resistor r=0.25k
	r_425 (n_425 n_424) resistor r=0.25k
	r_424 (n_424 n_423) resistor r=0.25k
	r_423 (n_423 n_422) resistor r=0.25k
	r_422 (n_422 n_421) resistor r=0.25k
	r_421 (n_421 n_420) resistor r=0.25k
	r_420 (n_420 n_419) resistor r=0.25k
	r_419 (n_419 n_418) resistor r=0.25k
	r_418 (n_418 n_417) resistor r=0.25k
	r_417 (n_417 n_416) resistor r=0.25k
	r_416 (n_416 n_415) resistor r=0.25k
	r_415 (n_415 n_414) resistor r=0.25k
	r_414 (n_414 n_413) resistor r=0.25k
	r_413 (n_413 n_412) resistor r=0.25k
	r_412 (n_412 n_411) resistor r=0.25k
	r_411 (n_411 n_410) resistor r=0.25k
	r_410 (n_410 n_409) resistor r=0.25k
	r_409 (n_409 n_408) resistor r=0.25k
	r_408 (n_408 n_407) resistor r=0.25k
	r_407 (n_407 n_406) resistor r=0.25k
	r_406 (n_406 n_405) resistor r=0.25k
	r_405 (n_405 n_404) resistor r=0.25k
	r_404 (n_404 n_403) resistor r=0.25k
	r_403 (n_403 n_402) resistor r=0.25k
	r_402 (n_402 n_401) resistor r=0.25k
	r_401 (n_401 n_400) resistor r=0.25k
	r_400 (n_400 n_399) resistor r=0.25k
	r_399 (n_399 n_398) resistor r=0.25k
	r_398 (n_398 n_397) resistor r=0.25k
	r_397 (n_397 n_396) resistor r=0.25k
	r_396 (n_396 n_395) resistor r=0.25k
	r_395 (n_395 n_394) resistor r=0.25k
	r_394 (n_394 n_393) resistor r=0.25k
	r_393 (n_393 n_392) resistor r=0.25k
	r_392 (n_392 n_391) resistor r=0.25k
	r_391 (n_391 n_390) resistor r=0.25k
	r_390 (n_390 n_389) resistor r=0.25k
	r_389 (n_389 n_388) resistor r=0.25k
	r_388 (n_388 n_387) resistor r=0.25k
	r_387 (n_387 n_386) resistor r=0.25k
	r_386 (n_386 n_385) resistor r=0.25k
	r_385 (n_385 n_384) resistor r=0.25k
	r_384 (n_384 n_383) resistor r=0.25k
	r_383 (n_383 n_382) resistor r=0.25k
	r_382 (n_382 n_381) resistor r=0.25k
	r_381 (n_381 n_380) resistor r=0.25k
	r_380 (n_380 n_379) resistor r=0.25k
	r_379 (n_379 n_378) resistor r=0.25k
	r_378 (n_378 n_377) resistor r=0.25k
	r_377 (n_377 n_376) resistor r=0.25k
	r_376 (n_376 n_375) resistor r=0.25k
	r_375 (n_375 n_374) resistor r=0.25k
	r_374 (n_374 n_373) resistor r=0.25k
	r_373 (n_373 n_372) resistor r=0.25k
	r_372 (n_372 n_371) resistor r=0.25k
	r_371 (n_371 n_370) resistor r=0.25k
	r_370 (n_370 n_369) resistor r=0.25k
	r_369 (n_369 n_368) resistor r=0.25k
	r_368 (n_368 n_367) resistor r=0.25k
	r_367 (n_367 n_366) resistor r=0.25k
	r_366 (n_366 n_365) resistor r=0.25k
	r_365 (n_365 n_364) resistor r=0.25k
	r_364 (n_364 n_363) resistor r=0.25k
	r_363 (n_363 n_362) resistor r=0.25k
	r_362 (n_362 n_361) resistor r=0.25k
	r_361 (n_361 n_360) resistor r=0.25k
	r_360 (n_360 n_359) resistor r=0.25k
	r_359 (n_359 n_358) resistor r=0.25k
	r_358 (n_358 n_357) resistor r=0.25k
	r_357 (n_357 n_356) resistor r=0.25k
	r_356 (n_356 n_355) resistor r=0.25k
	r_355 (n_355 n_354) resistor r=0.25k
	r_354 (n_354 n_353) resistor r=0.25k
	r_353 (n_353 n_352) resistor r=0.25k
	r_352 (n_352 n_351) resistor r=0.25k
	r_351 (n_351 n_350) resistor r=0.25k
	r_350 (n_350 n_349) resistor r=0.25k
	r_349 (n_349 n_348) resistor r=0.25k
	r_348 (n_348 n_347) resistor r=0.25k
	r_347 (n_347 n_346) resistor r=0.25k
	r_346 (n_346 n_345) resistor r=0.25k
	r_345 (n_345 n_344) resistor r=0.25k
	r_344 (n_344 n_343) resistor r=0.25k
	r_343 (n_343 n_342) resistor r=0.25k
	r_342 (n_342 n_341) resistor r=0.25k
	r_341 (n_341 n_340) resistor r=0.25k
	r_340 (n_340 n_339) resistor r=0.25k
	r_339 (n_339 n_338) resistor r=0.25k
	r_338 (n_338 n_337) resistor r=0.25k
	r_337 (n_337 n_336) resistor r=0.25k
	r_336 (n_336 n_335) resistor r=0.25k
	r_335 (n_335 n_334) resistor r=0.25k
	r_334 (n_334 n_333) resistor r=0.25k
	r_333 (n_333 n_332) resistor r=0.25k
	r_332 (n_332 n_331) resistor r=0.25k
	r_331 (n_331 n_330) resistor r=0.25k
	r_330 (n_330 n_329) resistor r=0.25k
	r_329 (n_329 n_328) resistor r=0.25k
	r_328 (n_328 n_327) resistor r=0.25k
	r_327 (n_327 n_326) resistor r=0.25k
	r_326 (n_326 n_325) resistor r=0.25k
	r_325 (n_325 n_324) resistor r=0.25k
	r_324 (n_324 n_323) resistor r=0.25k
	r_323 (n_323 n_322) resistor r=0.25k
	r_322 (n_322 n_321) resistor r=0.25k
	r_321 (n_321 n_320) resistor r=0.25k
	r_320 (n_320 n_319) resistor r=0.25k
	r_319 (n_319 n_318) resistor r=0.25k
	r_318 (n_318 n_317) resistor r=0.25k
	r_317 (n_317 n_316) resistor r=0.25k
	r_316 (n_316 n_315) resistor r=0.25k
	r_315 (n_315 n_314) resistor r=0.25k
	r_314 (n_314 n_313) resistor r=0.25k
	r_313 (n_313 n_312) resistor r=0.25k
	r_312 (n_312 n_311) resistor r=0.25k
	r_311 (n_311 n_310) resistor r=0.25k
	r_310 (n_310 n_309) resistor r=0.25k
	r_309 (n_309 n_308) resistor r=0.25k
	r_308 (n_308 n_307) resistor r=0.25k
	r_307 (n_307 n_306) resistor r=0.25k
	r_306 (n_306 n_305) resistor r=0.25k
	r_305 (n_305 n_304) resistor r=0.25k
	r_304 (n_304 n_303) resistor r=0.25k
	r_303 (n_303 n_302) resistor r=0.25k
	r_302 (n_302 n_301) resistor r=0.25k
	r_301 (n_301 n_300) resistor r=0.25k
	r_300 (n_300 n_299) resistor r=0.25k
	r_299 (n_299 n_298) resistor r=0.25k
	r_298 (n_298 n_297) resistor r=0.25k
	r_297 (n_297 n_296) resistor r=0.25k
	r_296 (n_296 n_295) resistor r=0.25k
	r_295 (n_295 n_294) resistor r=0.25k
	r_294 (n_294 n_293) resistor r=0.25k
	r_293 (n_293 n_292) resistor r=0.25k
	r_292 (n_292 n_291) resistor r=0.25k
	r_291 (n_291 n_290) resistor r=0.25k
	r_290 (n_290 n_289) resistor r=0.25k
	r_289 (n_289 n_288) resistor r=0.25k
	r_288 (n_288 n_287) resistor r=0.25k
	r_287 (n_287 n_286) resistor r=0.25k
	r_286 (n_286 n_285) resistor r=0.25k
	r_285 (n_285 n_284) resistor r=0.25k
	r_284 (n_284 n_283) resistor r=0.25k
	r_283 (n_283 n_282) resistor r=0.25k
	r_282 (n_282 n_281) resistor r=0.25k
	r_281 (n_281 n_280) resistor r=0.25k
	r_280 (n_280 n_279) resistor r=0.25k
	r_279 (n_279 n_278) resistor r=0.25k
	r_278 (n_278 n_277) resistor r=0.25k
	r_277 (n_277 n_276) resistor r=0.25k
	r_276 (n_276 n_275) resistor r=0.25k
	r_275 (n_275 n_274) resistor r=0.25k
	r_274 (n_274 n_273) resistor r=0.25k
	r_273 (n_273 n_272) resistor r=0.25k
	r_272 (n_272 n_271) resistor r=0.25k
	r_271 (n_271 n_270) resistor r=0.25k
	r_270 (n_270 n_269) resistor r=0.25k
	r_269 (n_269 n_268) resistor r=0.25k
	r_268 (n_268 n_267) resistor r=0.25k
	r_267 (n_267 n_266) resistor r=0.25k
	r_266 (n_266 n_265) resistor r=0.25k
	r_265 (n_265 n_264) resistor r=0.25k
	r_264 (n_264 n_263) resistor r=0.25k
	r_263 (n_263 n_262) resistor r=0.25k
	r_262 (n_262 n_261) resistor r=0.25k
	r_261 (n_261 n_260) resistor r=0.25k
	r_260 (n_260 n_259) resistor r=0.25k
	r_259 (n_259 n_258) resistor r=0.25k
	r_258 (n_258 n_257) resistor r=0.25k
	r_257 (n_257 n_256) resistor r=0.25k
	r_256 (n_256 n_255) resistor r=0.25k
	r_255 (n_255 n_254) resistor r=0.25k
	r_254 (n_254 n_253) resistor r=0.25k
	r_253 (n_253 n_252) resistor r=0.25k
	r_252 (n_252 n_251) resistor r=0.25k
	r_251 (n_251 n_250) resistor r=0.25k
	r_250 (n_250 n_249) resistor r=0.25k
	r_249 (n_249 n_248) resistor r=0.25k
	r_248 (n_248 n_247) resistor r=0.25k
	r_247 (n_247 n_246) resistor r=0.25k
	r_246 (n_246 n_245) resistor r=0.25k
	r_245 (n_245 n_244) resistor r=0.25k
	r_244 (n_244 n_243) resistor r=0.25k
	r_243 (n_243 n_242) resistor r=0.25k
	r_242 (n_242 n_241) resistor r=0.25k
	r_241 (n_241 n_240) resistor r=0.25k
	r_240 (n_240 n_239) resistor r=0.25k
	r_239 (n_239 n_238) resistor r=0.25k
	r_238 (n_238 n_237) resistor r=0.25k
	r_237 (n_237 n_236) resistor r=0.25k
	r_236 (n_236 n_235) resistor r=0.25k
	r_235 (n_235 n_234) resistor r=0.25k
	r_234 (n_234 n_233) resistor r=0.25k
	r_233 (n_233 n_232) resistor r=0.25k
	r_232 (n_232 n_231) resistor r=0.25k
	r_231 (n_231 n_230) resistor r=0.25k
	r_230 (n_230 n_229) resistor r=0.25k
	r_229 (n_229 n_228) resistor r=0.25k
	r_228 (n_228 n_227) resistor r=0.25k
	r_227 (n_227 n_226) resistor r=0.25k
	r_226 (n_226 n_225) resistor r=0.25k
	r_225 (n_225 n_224) resistor r=0.25k
	r_224 (n_224 n_223) resistor r=0.25k
	r_223 (n_223 n_222) resistor r=0.25k
	r_222 (n_222 n_221) resistor r=0.25k
	r_221 (n_221 n_220) resistor r=0.25k
	r_220 (n_220 n_219) resistor r=0.25k
	r_219 (n_219 n_218) resistor r=0.25k
	r_218 (n_218 n_217) resistor r=0.25k
	r_217 (n_217 n_216) resistor r=0.25k
	r_216 (n_216 n_215) resistor r=0.25k
	r_215 (n_215 n_214) resistor r=0.25k
	r_214 (n_214 n_213) resistor r=0.25k
	r_213 (n_213 n_212) resistor r=0.25k
	r_212 (n_212 n_211) resistor r=0.25k
	r_211 (n_211 n_210) resistor r=0.25k
	r_210 (n_210 n_209) resistor r=0.25k
	r_209 (n_209 n_208) resistor r=0.25k
	r_208 (n_208 n_207) resistor r=0.25k
	r_207 (n_207 n_206) resistor r=0.25k
	r_206 (n_206 n_205) resistor r=0.25k
	r_205 (n_205 n_204) resistor r=0.25k
	r_204 (n_204 n_203) resistor r=0.25k
	r_203 (n_203 n_202) resistor r=0.25k
	r_202 (n_202 n_201) resistor r=0.25k
	r_201 (n_201 n_200) resistor r=0.25k
	r_200 (n_200 n_199) resistor r=0.25k
	r_199 (n_199 n_198) resistor r=0.25k
	r_198 (n_198 n_197) resistor r=0.25k
	r_197 (n_197 n_196) resistor r=0.25k
	r_196 (n_196 n_195) resistor r=0.25k
	r_195 (n_195 n_194) resistor r=0.25k
	r_194 (n_194 n_193) resistor r=0.25k
	r_193 (n_193 n_192) resistor r=0.25k
	r_192 (n_192 n_191) resistor r=0.25k
	r_191 (n_191 n_190) resistor r=0.25k
	r_190 (n_190 n_189) resistor r=0.25k
	r_189 (n_189 n_188) resistor r=0.25k
	r_188 (n_188 n_187) resistor r=0.25k
	r_187 (n_187 n_186) resistor r=0.25k
	r_186 (n_186 n_185) resistor r=0.25k
	r_185 (n_185 n_184) resistor r=0.25k
	r_184 (n_184 n_183) resistor r=0.25k
	r_183 (n_183 n_182) resistor r=0.25k
	r_182 (n_182 n_181) resistor r=0.25k
	r_181 (n_181 n_180) resistor r=0.25k
	r_180 (n_180 n_179) resistor r=0.25k
	r_179 (n_179 n_178) resistor r=0.25k
	r_178 (n_178 n_177) resistor r=0.25k
	r_177 (n_177 n_176) resistor r=0.25k
	r_176 (n_176 n_175) resistor r=0.25k
	r_175 (n_175 n_174) resistor r=0.25k
	r_174 (n_174 n_173) resistor r=0.25k
	r_173 (n_173 n_172) resistor r=0.25k
	r_172 (n_172 n_171) resistor r=0.25k
	r_171 (n_171 n_170) resistor r=0.25k
	r_170 (n_170 n_169) resistor r=0.25k
	r_169 (n_169 n_168) resistor r=0.25k
	r_168 (n_168 n_167) resistor r=0.25k
	r_167 (n_167 n_166) resistor r=0.25k
	r_166 (n_166 n_165) resistor r=0.25k
	r_165 (n_165 n_164) resistor r=0.25k
	r_164 (n_164 n_163) resistor r=0.25k
	r_163 (n_163 n_162) resistor r=0.25k
	r_162 (n_162 n_161) resistor r=0.25k
	r_161 (n_161 n_160) resistor r=0.25k
	r_160 (n_160 n_159) resistor r=0.25k
	r_159 (n_159 n_158) resistor r=0.25k
	r_158 (n_158 n_157) resistor r=0.25k
	r_157 (n_157 n_156) resistor r=0.25k
	r_156 (n_156 n_155) resistor r=0.25k
	r_155 (n_155 n_154) resistor r=0.25k
	r_154 (n_154 n_153) resistor r=0.25k
	r_153 (n_153 n_152) resistor r=0.25k
	r_152 (n_152 n_151) resistor r=0.25k
	r_151 (n_151 n_150) resistor r=0.25k
	r_150 (n_150 n_149) resistor r=0.25k
	r_149 (n_149 n_148) resistor r=0.25k
	r_148 (n_148 n_147) resistor r=0.25k
	r_147 (n_147 n_146) resistor r=0.25k
	r_146 (n_146 n_145) resistor r=0.25k
	r_145 (n_145 n_144) resistor r=0.25k
	r_144 (n_144 n_143) resistor r=0.25k
	r_143 (n_143 n_142) resistor r=0.25k
	r_142 (n_142 n_141) resistor r=0.25k
	r_141 (n_141 n_140) resistor r=0.25k
	r_140 (n_140 n_139) resistor r=0.25k
	r_139 (n_139 n_138) resistor r=0.25k
	r_138 (n_138 n_137) resistor r=0.25k
	r_137 (n_137 n_136) resistor r=0.25k
	r_136 (n_136 n_135) resistor r=0.25k
	r_135 (n_135 n_134) resistor r=0.25k
	r_134 (n_134 n_133) resistor r=0.25k
	r_133 (n_133 n_132) resistor r=0.25k
	r_132 (n_132 n_131) resistor r=0.25k
	r_131 (n_131 n_130) resistor r=0.25k
	r_130 (n_130 n_129) resistor r=0.25k
	r_129 (n_129 n_128) resistor r=0.25k
	r_128 (n_128 n_127) resistor r=0.25k
	r_127 (n_127 n_126) resistor r=0.25k
	r_126 (n_126 n_125) resistor r=0.25k
	r_125 (n_125 n_124) resistor r=0.25k
	r_124 (n_124 n_123) resistor r=0.25k
	r_123 (n_123 n_122) resistor r=0.25k
	r_122 (n_122 n_121) resistor r=0.25k
	r_121 (n_121 n_120) resistor r=0.25k
	r_120 (n_120 n_119) resistor r=0.25k
	r_119 (n_119 n_118) resistor r=0.25k
	r_118 (n_118 n_117) resistor r=0.25k
	r_117 (n_117 n_116) resistor r=0.25k
	r_116 (n_116 n_115) resistor r=0.25k
	r_115 (n_115 n_114) resistor r=0.25k
	r_114 (n_114 n_113) resistor r=0.25k
	r_113 (n_113 n_112) resistor r=0.25k
	r_112 (n_112 n_111) resistor r=0.25k
	r_111 (n_111 n_110) resistor r=0.25k
	r_110 (n_110 n_109) resistor r=0.25k
	r_109 (n_109 n_108) resistor r=0.25k
	r_108 (n_108 n_107) resistor r=0.25k
	r_107 (n_107 n_106) resistor r=0.25k
	r_106 (n_106 n_105) resistor r=0.25k
	r_105 (n_105 n_104) resistor r=0.25k
	r_104 (n_104 n_103) resistor r=0.25k
	r_103 (n_103 n_102) resistor r=0.25k
	r_102 (n_102 n_101) resistor r=0.25k
	r_101 (n_101 n_100) resistor r=0.25k
	r_100 (n_100 n_99) resistor r=0.25k
	r_99 (n_99 n_98) resistor r=0.25k
	r_98 (n_98 n_97) resistor r=0.25k
	r_97 (n_97 n_96) resistor r=0.25k
	r_96 (n_96 n_95) resistor r=0.25k
	r_95 (n_95 n_94) resistor r=0.25k
	r_94 (n_94 n_93) resistor r=0.25k
	r_93 (n_93 n_92) resistor r=0.25k
	r_92 (n_92 n_91) resistor r=0.25k
	r_91 (n_91 n_90) resistor r=0.25k
	r_90 (n_90 n_89) resistor r=0.25k
	r_89 (n_89 n_88) resistor r=0.25k
	r_88 (n_88 n_87) resistor r=0.25k
	r_87 (n_87 n_86) resistor r=0.25k
	r_86 (n_86 n_85) resistor r=0.25k
	r_85 (n_85 n_84) resistor r=0.25k
	r_84 (n_84 n_83) resistor r=0.25k
	r_83 (n_83 n_82) resistor r=0.25k
	r_82 (n_82 n_81) resistor r=0.25k
	r_81 (n_81 n_80) resistor r=0.25k
	r_80 (n_80 n_79) resistor r=0.25k
	r_79 (n_79 n_78) resistor r=0.25k
	r_78 (n_78 n_77) resistor r=0.25k
	r_77 (n_77 n_76) resistor r=0.25k
	r_76 (n_76 n_75) resistor r=0.25k
	r_75 (n_75 n_74) resistor r=0.25k
	r_74 (n_74 n_73) resistor r=0.25k
	r_73 (n_73 n_72) resistor r=0.25k
	r_72 (n_72 n_71) resistor r=0.25k
	r_71 (n_71 n_70) resistor r=0.25k
	r_70 (n_70 n_69) resistor r=0.25k
	r_69 (n_69 n_68) resistor r=0.25k
	r_68 (n_68 n_67) resistor r=0.25k
	r_67 (n_67 n_66) resistor r=0.25k
	r_66 (n_66 n_65) resistor r=0.25k
	r_65 (n_65 n_64) resistor r=0.25k
	r_64 (n_64 n_63) resistor r=0.25k
	r_63 (n_63 n_62) resistor r=0.25k
	r_62 (n_62 n_61) resistor r=0.25k
	r_61 (n_61 n_60) resistor r=0.25k
	r_60 (n_60 n_59) resistor r=0.25k
	r_59 (n_59 n_58) resistor r=0.25k
	r_58 (n_58 n_57) resistor r=0.25k
	r_57 (n_57 n_56) resistor r=0.25k
	r_56 (n_56 n_55) resistor r=0.25k
	r_55 (n_55 n_54) resistor r=0.25k
	r_54 (n_54 n_53) resistor r=0.25k
	r_53 (n_53 n_52) resistor r=0.25k
	r_52 (n_52 n_51) resistor r=0.25k
	r_51 (n_51 n_50) resistor r=0.25k
	r_50 (n_50 n_49) resistor r=0.25k
	r_49 (n_49 n_48) resistor r=0.25k
	r_48 (n_48 n_47) resistor r=0.25k
	r_47 (n_47 n_46) resistor r=0.25k
	r_46 (n_46 n_45) resistor r=0.25k
	r_45 (n_45 n_44) resistor r=0.25k
	r_44 (n_44 n_43) resistor r=0.25k
	r_43 (n_43 n_42) resistor r=0.25k
	r_42 (n_42 n_41) resistor r=0.25k
	r_41 (n_41 n_40) resistor r=0.25k
	r_40 (n_40 n_39) resistor r=0.25k
	r_39 (n_39 n_38) resistor r=0.25k
	r_38 (n_38 n_37) resistor r=0.25k
	r_37 (n_37 n_36) resistor r=0.25k
	r_36 (n_36 n_35) resistor r=0.25k
	r_35 (n_35 n_34) resistor r=0.25k
	r_34 (n_34 n_33) resistor r=0.25k
	r_33 (n_33 n_32) resistor r=0.25k
	r_32 (n_32 n_31) resistor r=0.25k
	r_31 (n_31 n_30) resistor r=0.25k
	r_30 (n_30 n_29) resistor r=0.25k
	r_29 (n_29 n_28) resistor r=0.25k
	r_28 (n_28 n_27) resistor r=0.25k
	r_27 (n_27 n_26) resistor r=0.25k
	r_26 (n_26 n_25) resistor r=0.25k
	r_25 (n_25 n_24) resistor r=0.25k
	r_24 (n_24 n_23) resistor r=0.25k
	r_23 (n_23 n_22) resistor r=0.25k
	r_22 (n_22 n_21) resistor r=0.25k
	r_21 (n_21 n_20) resistor r=0.25k
	r_20 (n_20 n_19) resistor r=0.25k
	r_19 (n_19 n_18) resistor r=0.25k
	r_18 (n_18 n_17) resistor r=0.25k
	r_17 (n_17 n_16) resistor r=0.25k
	r_16 (n_16 n_15) resistor r=0.25k
	r_15 (n_15 n_14) resistor r=0.25k
	r_14 (n_14 n_13) resistor r=0.25k
	r_13 (n_13 n_12) resistor r=0.25k
	r_12 (n_12 n_11) resistor r=0.25k
	r_11 (n_11 n_10) resistor r=0.25k
	r_10 (n_10 n_9) resistor r=0.25k
	r_9 (n_9 n_8) resistor r=0.25k
	r_8 (n_8 n_7) resistor r=0.25k
	r_7 (n_7 n_6) resistor r=0.25k
	r_6 (n_6 n_5) resistor r=0.25k
	r_5 (n_5 n_4) resistor r=0.25k
	r_4 (n_4 n_3) resistor r=0.25k
	r_3 (n_3 n_2) resistor r=0.25k
	r_2 (n_2 n_1) resistor r=0.25k
	r_1 (n_1 n_0) resistor r=0.25k
	r_0 (n_0 0) resistor r=0.25k

	// analog_mux connection

	m_0 (n_1023 n_1022 n_1021 n_1020
		+ n_1019 n_1018 n_1017 n_1016 n_1015 n_1014 n_1013 n_1012 n_1011 n_1010
		+ n_1009 n_1008 n_1007 n_1006 n_1005 n_1004 n_1003 n_1002 n_1001 n_1000
		+ n_999 n_998 n_997 n_996 n_995 n_994 n_993 n_992 n_991 n_990
		+ n_989 n_988 n_987 n_986 n_985 n_984 n_983 n_982 n_981 n_980
		+ n_979 n_978 n_977 n_976 n_975 n_974 n_973 n_972 n_971 n_970
		+ n_969 n_968 n_967 n_966 n_965 n_964 n_963 n_962 n_961 n_960
		+ n_959 n_958 n_957 n_956 n_955 n_954 n_953 n_952 n_951 n_950
		+ n_949 n_948 n_947 n_946 n_945 n_944 n_943 n_942 n_941 n_940
		+ n_939 n_938 n_937 n_936 n_935 n_934 n_933 n_932 n_931 n_930
		+ n_929 n_928 n_927 n_926 n_925 n_924 n_923 n_922 n_921 n_920
		+ n_919 n_918 n_917 n_916 n_915 n_914 n_913 n_912 n_911 n_910
		+ n_909 n_908 n_907 n_906 n_905 n_904 n_903 n_902 n_901 n_900
		+ n_899 n_898 n_897 n_896 n_895 n_894 n_893 n_892 n_891 n_890
		+ n_889 n_888 n_887 n_886 n_885 n_884 n_883 n_882 n_881 n_880
		+ n_879 n_878 n_877 n_876 n_875 n_874 n_873 n_872 n_871 n_870
		+ n_869 n_868 n_867 n_866 n_865 n_864 n_863 n_862 n_861 n_860
		+ n_859 n_858 n_857 n_856 n_855 n_854 n_853 n_852 n_851 n_850
		+ n_849 n_848 n_847 n_846 n_845 n_844 n_843 n_842 n_841 n_840
		+ n_839 n_838 n_837 n_836 n_835 n_834 n_833 n_832 n_831 n_830
		+ n_829 n_828 n_827 n_826 n_825 n_824 n_823 n_822 n_821 n_820
		+ n_819 n_818 n_817 n_816 n_815 n_814 n_813 n_812 n_811 n_810
		+ n_809 n_808 n_807 n_806 n_805 n_804 n_803 n_802 n_801 n_800
		+ n_799 n_798 n_797 n_796 n_795 n_794 n_793 n_792 n_791 n_790
		+ n_789 n_788 n_787 n_786 n_785 n_784 n_783 n_782 n_781 n_780
		+ n_779 n_778 n_777 n_776 n_775 n_774 n_773 n_772 n_771 n_770
		+ n_769 n_768 n_767 n_766 n_765 n_764 n_763 n_762 n_761 n_760
		+ n_759 n_758 n_757 n_756 n_755 n_754 n_753 n_752 n_751 n_750
		+ n_749 n_748 n_747 n_746 n_745 n_744 n_743 n_742 n_741 n_740
		+ n_739 n_738 n_737 n_736 n_735 n_734 n_733 n_732 n_731 n_730
		+ n_729 n_728 n_727 n_726 n_725 n_724 n_723 n_722 n_721 n_720
		+ n_719 n_718 n_717 n_716 n_715 n_714 n_713 n_712 n_711 n_710
		+ n_709 n_708 n_707 n_706 n_705 n_704 n_703 n_702 n_701 n_700
		+ n_699 n_698 n_697 n_696 n_695 n_694 n_693 n_692 n_691 n_690
		+ n_689 n_688 n_687 n_686 n_685 n_684 n_683 n_682 n_681 n_680
		+ n_679 n_678 n_677 n_676 n_675 n_674 n_673 n_672 n_671 n_670
		+ n_669 n_668 n_667 n_666 n_665 n_664 n_663 n_662 n_661 n_660
		+ n_659 n_658 n_657 n_656 n_655 n_654 n_653 n_652 n_651 n_650
		+ n_649 n_648 n_647 n_646 n_645 n_644 n_643 n_642 n_641 n_640
		+ n_639 n_638 n_637 n_636 n_635 n_634 n_633 n_632 n_631 n_630
		+ n_629 n_628 n_627 n_626 n_625 n_624 n_623 n_622 n_621 n_620
		+ n_619 n_618 n_617 n_616 n_615 n_614 n_613 n_612 n_611 n_610
		+ n_609 n_608 n_607 n_606 n_605 n_604 n_603 n_602 n_601 n_600
		+ n_599 n_598 n_597 n_596 n_595 n_594 n_593 n_592 n_591 n_590
		+ n_589 n_588 n_587 n_586 n_585 n_584 n_583 n_582 n_581 n_580
		+ n_579 n_578 n_577 n_576 n_575 n_574 n_573 n_572 n_571 n_570
		+ n_569 n_568 n_567 n_566 n_565 n_564 n_563 n_562 n_561 n_560
		+ n_559 n_558 n_557 n_556 n_555 n_554 n_553 n_552 n_551 n_550
		+ n_549 n_548 n_547 n_546 n_545 n_544 n_543 n_542 n_541 n_540
		+ n_539 n_538 n_537 n_536 n_535 n_534 n_533 n_532 n_531 n_530
		+ n_529 n_528 n_527 n_526 n_525 n_524 n_523 n_522 n_521 n_520
		+ n_519 n_518 n_517 n_516 n_515 n_514 n_513 n_512 n_511 n_510
		+ n_509 n_508 n_507 n_506 n_505 n_504 n_503 n_502 n_501 n_500
		+ n_499 n_498 n_497 n_496 n_495 n_494 n_493 n_492 n_491 n_490
		+ n_489 n_488 n_487 n_486 n_485 n_484 n_483 n_482 n_481 n_480
		+ n_479 n_478 n_477 n_476 n_475 n_474 n_473 n_472 n_471 n_470
		+ n_469 n_468 n_467 n_466 n_465 n_464 n_463 n_462 n_461 n_460
		+ n_459 n_458 n_457 n_456 n_455 n_454 n_453 n_452 n_451 n_450
		+ n_449 n_448 n_447 n_446 n_445 n_444 n_443 n_442 n_441 n_440
		+ n_439 n_438 n_437 n_436 n_435 n_434 n_433 n_432 n_431 n_430
		+ n_429 n_428 n_427 n_426 n_425 n_424 n_423 n_422 n_421 n_420
		+ n_419 n_418 n_417 n_416 n_415 n_414 n_413 n_412 n_411 n_410
		+ n_409 n_408 n_407 n_406 n_405 n_404 n_403 n_402 n_401 n_400
		+ n_399 n_398 n_397 n_396 n_395 n_394 n_393 n_392 n_391 n_390
		+ n_389 n_388 n_387 n_386 n_385 n_384 n_383 n_382 n_381 n_380
		+ n_379 n_378 n_377 n_376 n_375 n_374 n_373 n_372 n_371 n_370
		+ n_369 n_368 n_367 n_366 n_365 n_364 n_363 n_362 n_361 n_360
		+ n_359 n_358 n_357 n_356 n_355 n_354 n_353 n_352 n_351 n_350
		+ n_349 n_348 n_347 n_346 n_345 n_344 n_343 n_342 n_341 n_340
		+ n_339 n_338 n_337 n_336 n_335 n_334 n_333 n_332 n_331 n_330
		+ n_329 n_328 n_327 n_326 n_325 n_324 n_323 n_322 n_321 n_320
		+ n_319 n_318 n_317 n_316 n_315 n_314 n_313 n_312 n_311 n_310
		+ n_309 n_308 n_307 n_306 n_305 n_304 n_303 n_302 n_301 n_300
		+ n_299 n_298 n_297 n_296 n_295 n_294 n_293 n_292 n_291 n_290
		+ n_289 n_288 n_287 n_286 n_285 n_284 n_283 n_282 n_281 n_280
		+ n_279 n_278 n_277 n_276 n_275 n_274 n_273 n_272 n_271 n_270
		+ n_269 n_268 n_267 n_266 n_265 n_264 n_263 n_262 n_261 n_260
		+ n_259 n_258 n_257 n_256 n_255 n_254 n_253 n_252 n_251 n_250
		+ n_249 n_248 n_247 n_246 n_245 n_244 n_243 n_242 n_241 n_240
		+ n_239 n_238 n_237 n_236 n_235 n_234 n_233 n_232 n_231 n_230
		+ n_229 n_228 n_227 n_226 n_225 n_224 n_223 n_222 n_221 n_220
		+ n_219 n_218 n_217 n_216 n_215 n_214 n_213 n_212 n_211 n_210
		+ n_209 n_208 n_207 n_206 n_205 n_204 n_203 n_202 n_201 n_200
		+ n_199 n_198 n_197 n_196 n_195 n_194 n_193 n_192 n_191 n_190
		+ n_189 n_188 n_187 n_186 n_185 n_184 n_183 n_182 n_181 n_180
		+ n_179 n_178 n_177 n_176 n_175 n_174 n_173 n_172 n_171 n_170
		+ n_169 n_168 n_167 n_166 n_165 n_164 n_163 n_162 n_161 n_160
		+ n_159 n_158 n_157 n_156 n_155 n_154 n_153 n_152 n_151 n_150
		+ n_149 n_148 n_147 n_146 n_145 n_144 n_143 n_142 n_141 n_140
		+ n_139 n_138 n_137 n_136 n_135 n_134 n_133 n_132 n_131 n_130
		+ n_129 n_128 n_127 n_126 n_125 n_124 n_123 n_122 n_121 n_120
		+ n_119 n_118 n_117 n_116 n_115 n_114 n_113 n_112 n_111 n_110
		+ n_109 n_108 n_107 n_106 n_105 n_104 n_103 n_102 n_101 n_100
		+ n_99 n_98 n_97 n_96 n_95 n_94 n_93 n_92 n_91 n_90
		+ n_89 n_88 n_87 n_86 n_85 n_84 n_83 n_82 n_81 n_80
		+ n_79 n_78 n_77 n_76 n_75 n_74 n_73 n_72 n_71 n_70
		+ n_69 n_68 n_67 n_66 n_65 n_64 n_63 n_62 n_61 n_60
		+ n_59 n_58 n_57 n_56 n_55 n_54 n_53 n_52 n_51 n_50
		+ n_49 n_48 n_47 n_46 n_45 n_44 n_43 n_42 n_41 n_40
		+ n_39 n_38 n_37 n_36 n_35 n_34 n_33 n_32 n_31 n_30
		+ n_29 n_28 n_27 n_26 n_25 n_24 n_23 n_22 n_21 n_20
		+ n_19 n_18 n_17 n_16 n_15 n_14 n_13 n_12 n_11 n_10
		+ n_9 n_8 n_7 n_6 n_5 n_4 n_3 n_2 n_1 n_0
		+  to_rram) analog_mux level=mux_level

ends resistive_loads
