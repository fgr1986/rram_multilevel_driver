`include "constants.vams"
`include "disciplines.vams"

module analog_mux(n_out, n_in);

	parameter level=0;
	inout n_in;
	electrical n_in;
	inout [1023:0] n_out;
	electrical [1023:0] n_out;
	integer select;
	genvar c;

	analog begin
		select = level;
		generate c (0,1023,1) begin
			if( c==select ) begin
				V(n_out[c], n_in) <+ 0;
			end else begin
				I(n_out[c], n_in) <+ 0;
			end
		end
	end
endmodule
