simulator lang=spectre

ahdl_include "analog_mux.va"

//////////////////////////////////
// Resistive loads and analog_mux cell //
// v0.1 24/10/2017              //
//////////////////////////////////

subckt resistive_loads (to_rram sel)

	r_511 (n_511 n_510 0) resistor r=0.5k
	r_510 (n_510 n_509 0) resistor r=0.5k
	r_509 (n_509 n_508 0) resistor r=0.5k
	r_508 (n_508 n_507 0) resistor r=0.5k
	r_507 (n_507 n_506 0) resistor r=0.5k
	r_506 (n_506 n_505 0) resistor r=0.5k
	r_505 (n_505 n_504 0) resistor r=0.5k
	r_504 (n_504 n_503 0) resistor r=0.5k
	r_503 (n_503 n_502 0) resistor r=0.5k
	r_502 (n_502 n_501 0) resistor r=0.5k
	r_501 (n_501 n_500 0) resistor r=0.5k
	r_500 (n_500 n_499 0) resistor r=0.5k
	r_499 (n_499 n_498 0) resistor r=0.5k
	r_498 (n_498 n_497 0) resistor r=0.5k
	r_497 (n_497 n_496 0) resistor r=0.5k
	r_496 (n_496 n_495 0) resistor r=0.5k
	r_495 (n_495 n_494 0) resistor r=0.5k
	r_494 (n_494 n_493 0) resistor r=0.5k
	r_493 (n_493 n_492 0) resistor r=0.5k
	r_492 (n_492 n_491 0) resistor r=0.5k
	r_491 (n_491 n_490 0) resistor r=0.5k
	r_490 (n_490 n_489 0) resistor r=0.5k
	r_489 (n_489 n_488 0) resistor r=0.5k
	r_488 (n_488 n_487 0) resistor r=0.5k
	r_487 (n_487 n_486 0) resistor r=0.5k
	r_486 (n_486 n_485 0) resistor r=0.5k
	r_485 (n_485 n_484 0) resistor r=0.5k
	r_484 (n_484 n_483 0) resistor r=0.5k
	r_483 (n_483 n_482 0) resistor r=0.5k
	r_482 (n_482 n_481 0) resistor r=0.5k
	r_481 (n_481 n_480 0) resistor r=0.5k
	r_480 (n_480 n_479 0) resistor r=0.5k
	r_479 (n_479 n_478 0) resistor r=0.5k
	r_478 (n_478 n_477 0) resistor r=0.5k
	r_477 (n_477 n_476 0) resistor r=0.5k
	r_476 (n_476 n_475 0) resistor r=0.5k
	r_475 (n_475 n_474 0) resistor r=0.5k
	r_474 (n_474 n_473 0) resistor r=0.5k
	r_473 (n_473 n_472 0) resistor r=0.5k
	r_472 (n_472 n_471 0) resistor r=0.5k
	r_471 (n_471 n_470 0) resistor r=0.5k
	r_470 (n_470 n_469 0) resistor r=0.5k
	r_469 (n_469 n_468 0) resistor r=0.5k
	r_468 (n_468 n_467 0) resistor r=0.5k
	r_467 (n_467 n_466 0) resistor r=0.5k
	r_466 (n_466 n_465 0) resistor r=0.5k
	r_465 (n_465 n_464 0) resistor r=0.5k
	r_464 (n_464 n_463 0) resistor r=0.5k
	r_463 (n_463 n_462 0) resistor r=0.5k
	r_462 (n_462 n_461 0) resistor r=0.5k
	r_461 (n_461 n_460 0) resistor r=0.5k
	r_460 (n_460 n_459 0) resistor r=0.5k
	r_459 (n_459 n_458 0) resistor r=0.5k
	r_458 (n_458 n_457 0) resistor r=0.5k
	r_457 (n_457 n_456 0) resistor r=0.5k
	r_456 (n_456 n_455 0) resistor r=0.5k
	r_455 (n_455 n_454 0) resistor r=0.5k
	r_454 (n_454 n_453 0) resistor r=0.5k
	r_453 (n_453 n_452 0) resistor r=0.5k
	r_452 (n_452 n_451 0) resistor r=0.5k
	r_451 (n_451 n_450 0) resistor r=0.5k
	r_450 (n_450 n_449 0) resistor r=0.5k
	r_449 (n_449 n_448 0) resistor r=0.5k
	r_448 (n_448 n_447 0) resistor r=0.5k
	r_447 (n_447 n_446 0) resistor r=0.5k
	r_446 (n_446 n_445 0) resistor r=0.5k
	r_445 (n_445 n_444 0) resistor r=0.5k
	r_444 (n_444 n_443 0) resistor r=0.5k
	r_443 (n_443 n_442 0) resistor r=0.5k
	r_442 (n_442 n_441 0) resistor r=0.5k
	r_441 (n_441 n_440 0) resistor r=0.5k
	r_440 (n_440 n_439 0) resistor r=0.5k
	r_439 (n_439 n_438 0) resistor r=0.5k
	r_438 (n_438 n_437 0) resistor r=0.5k
	r_437 (n_437 n_436 0) resistor r=0.5k
	r_436 (n_436 n_435 0) resistor r=0.5k
	r_435 (n_435 n_434 0) resistor r=0.5k
	r_434 (n_434 n_433 0) resistor r=0.5k
	r_433 (n_433 n_432 0) resistor r=0.5k
	r_432 (n_432 n_431 0) resistor r=0.5k
	r_431 (n_431 n_430 0) resistor r=0.5k
	r_430 (n_430 n_429 0) resistor r=0.5k
	r_429 (n_429 n_428 0) resistor r=0.5k
	r_428 (n_428 n_427 0) resistor r=0.5k
	r_427 (n_427 n_426 0) resistor r=0.5k
	r_426 (n_426 n_425 0) resistor r=0.5k
	r_425 (n_425 n_424 0) resistor r=0.5k
	r_424 (n_424 n_423 0) resistor r=0.5k
	r_423 (n_423 n_422 0) resistor r=0.5k
	r_422 (n_422 n_421 0) resistor r=0.5k
	r_421 (n_421 n_420 0) resistor r=0.5k
	r_420 (n_420 n_419 0) resistor r=0.5k
	r_419 (n_419 n_418 0) resistor r=0.5k
	r_418 (n_418 n_417 0) resistor r=0.5k
	r_417 (n_417 n_416 0) resistor r=0.5k
	r_416 (n_416 n_415 0) resistor r=0.5k
	r_415 (n_415 n_414 0) resistor r=0.5k
	r_414 (n_414 n_413 0) resistor r=0.5k
	r_413 (n_413 n_412 0) resistor r=0.5k
	r_412 (n_412 n_411 0) resistor r=0.5k
	r_411 (n_411 n_410 0) resistor r=0.5k
	r_410 (n_410 n_409 0) resistor r=0.5k
	r_409 (n_409 n_408 0) resistor r=0.5k
	r_408 (n_408 n_407 0) resistor r=0.5k
	r_407 (n_407 n_406 0) resistor r=0.5k
	r_406 (n_406 n_405 0) resistor r=0.5k
	r_405 (n_405 n_404 0) resistor r=0.5k
	r_404 (n_404 n_403 0) resistor r=0.5k
	r_403 (n_403 n_402 0) resistor r=0.5k
	r_402 (n_402 n_401 0) resistor r=0.5k
	r_401 (n_401 n_400 0) resistor r=0.5k
	r_400 (n_400 n_399 0) resistor r=0.5k
	r_399 (n_399 n_398 0) resistor r=0.5k
	r_398 (n_398 n_397 0) resistor r=0.5k
	r_397 (n_397 n_396 0) resistor r=0.5k
	r_396 (n_396 n_395 0) resistor r=0.5k
	r_395 (n_395 n_394 0) resistor r=0.5k
	r_394 (n_394 n_393 0) resistor r=0.5k
	r_393 (n_393 n_392 0) resistor r=0.5k
	r_392 (n_392 n_391 0) resistor r=0.5k
	r_391 (n_391 n_390 0) resistor r=0.5k
	r_390 (n_390 n_389 0) resistor r=0.5k
	r_389 (n_389 n_388 0) resistor r=0.5k
	r_388 (n_388 n_387 0) resistor r=0.5k
	r_387 (n_387 n_386 0) resistor r=0.5k
	r_386 (n_386 n_385 0) resistor r=0.5k
	r_385 (n_385 n_384 0) resistor r=0.5k
	r_384 (n_384 n_383 0) resistor r=0.5k
	r_383 (n_383 n_382 0) resistor r=0.5k
	r_382 (n_382 n_381 0) resistor r=0.5k
	r_381 (n_381 n_380 0) resistor r=0.5k
	r_380 (n_380 n_379 0) resistor r=0.5k
	r_379 (n_379 n_378 0) resistor r=0.5k
	r_378 (n_378 n_377 0) resistor r=0.5k
	r_377 (n_377 n_376 0) resistor r=0.5k
	r_376 (n_376 n_375 0) resistor r=0.5k
	r_375 (n_375 n_374 0) resistor r=0.5k
	r_374 (n_374 n_373 0) resistor r=0.5k
	r_373 (n_373 n_372 0) resistor r=0.5k
	r_372 (n_372 n_371 0) resistor r=0.5k
	r_371 (n_371 n_370 0) resistor r=0.5k
	r_370 (n_370 n_369 0) resistor r=0.5k
	r_369 (n_369 n_368 0) resistor r=0.5k
	r_368 (n_368 n_367 0) resistor r=0.5k
	r_367 (n_367 n_366 0) resistor r=0.5k
	r_366 (n_366 n_365 0) resistor r=0.5k
	r_365 (n_365 n_364 0) resistor r=0.5k
	r_364 (n_364 n_363 0) resistor r=0.5k
	r_363 (n_363 n_362 0) resistor r=0.5k
	r_362 (n_362 n_361 0) resistor r=0.5k
	r_361 (n_361 n_360 0) resistor r=0.5k
	r_360 (n_360 n_359 0) resistor r=0.5k
	r_359 (n_359 n_358 0) resistor r=0.5k
	r_358 (n_358 n_357 0) resistor r=0.5k
	r_357 (n_357 n_356 0) resistor r=0.5k
	r_356 (n_356 n_355 0) resistor r=0.5k
	r_355 (n_355 n_354 0) resistor r=0.5k
	r_354 (n_354 n_353 0) resistor r=0.5k
	r_353 (n_353 n_352 0) resistor r=0.5k
	r_352 (n_352 n_351 0) resistor r=0.5k
	r_351 (n_351 n_350 0) resistor r=0.5k
	r_350 (n_350 n_349 0) resistor r=0.5k
	r_349 (n_349 n_348 0) resistor r=0.5k
	r_348 (n_348 n_347 0) resistor r=0.5k
	r_347 (n_347 n_346 0) resistor r=0.5k
	r_346 (n_346 n_345 0) resistor r=0.5k
	r_345 (n_345 n_344 0) resistor r=0.5k
	r_344 (n_344 n_343 0) resistor r=0.5k
	r_343 (n_343 n_342 0) resistor r=0.5k
	r_342 (n_342 n_341 0) resistor r=0.5k
	r_341 (n_341 n_340 0) resistor r=0.5k
	r_340 (n_340 n_339 0) resistor r=0.5k
	r_339 (n_339 n_338 0) resistor r=0.5k
	r_338 (n_338 n_337 0) resistor r=0.5k
	r_337 (n_337 n_336 0) resistor r=0.5k
	r_336 (n_336 n_335 0) resistor r=0.5k
	r_335 (n_335 n_334 0) resistor r=0.5k
	r_334 (n_334 n_333 0) resistor r=0.5k
	r_333 (n_333 n_332 0) resistor r=0.5k
	r_332 (n_332 n_331 0) resistor r=0.5k
	r_331 (n_331 n_330 0) resistor r=0.5k
	r_330 (n_330 n_329 0) resistor r=0.5k
	r_329 (n_329 n_328 0) resistor r=0.5k
	r_328 (n_328 n_327 0) resistor r=0.5k
	r_327 (n_327 n_326 0) resistor r=0.5k
	r_326 (n_326 n_325 0) resistor r=0.5k
	r_325 (n_325 n_324 0) resistor r=0.5k
	r_324 (n_324 n_323 0) resistor r=0.5k
	r_323 (n_323 n_322 0) resistor r=0.5k
	r_322 (n_322 n_321 0) resistor r=0.5k
	r_321 (n_321 n_320 0) resistor r=0.5k
	r_320 (n_320 n_319 0) resistor r=0.5k
	r_319 (n_319 n_318 0) resistor r=0.5k
	r_318 (n_318 n_317 0) resistor r=0.5k
	r_317 (n_317 n_316 0) resistor r=0.5k
	r_316 (n_316 n_315 0) resistor r=0.5k
	r_315 (n_315 n_314 0) resistor r=0.5k
	r_314 (n_314 n_313 0) resistor r=0.5k
	r_313 (n_313 n_312 0) resistor r=0.5k
	r_312 (n_312 n_311 0) resistor r=0.5k
	r_311 (n_311 n_310 0) resistor r=0.5k
	r_310 (n_310 n_309 0) resistor r=0.5k
	r_309 (n_309 n_308 0) resistor r=0.5k
	r_308 (n_308 n_307 0) resistor r=0.5k
	r_307 (n_307 n_306 0) resistor r=0.5k
	r_306 (n_306 n_305 0) resistor r=0.5k
	r_305 (n_305 n_304 0) resistor r=0.5k
	r_304 (n_304 n_303 0) resistor r=0.5k
	r_303 (n_303 n_302 0) resistor r=0.5k
	r_302 (n_302 n_301 0) resistor r=0.5k
	r_301 (n_301 n_300 0) resistor r=0.5k
	r_300 (n_300 n_299 0) resistor r=0.5k
	r_299 (n_299 n_298 0) resistor r=0.5k
	r_298 (n_298 n_297 0) resistor r=0.5k
	r_297 (n_297 n_296 0) resistor r=0.5k
	r_296 (n_296 n_295 0) resistor r=0.5k
	r_295 (n_295 n_294 0) resistor r=0.5k
	r_294 (n_294 n_293 0) resistor r=0.5k
	r_293 (n_293 n_292 0) resistor r=0.5k
	r_292 (n_292 n_291 0) resistor r=0.5k
	r_291 (n_291 n_290 0) resistor r=0.5k
	r_290 (n_290 n_289 0) resistor r=0.5k
	r_289 (n_289 n_288 0) resistor r=0.5k
	r_288 (n_288 n_287 0) resistor r=0.5k
	r_287 (n_287 n_286 0) resistor r=0.5k
	r_286 (n_286 n_285 0) resistor r=0.5k
	r_285 (n_285 n_284 0) resistor r=0.5k
	r_284 (n_284 n_283 0) resistor r=0.5k
	r_283 (n_283 n_282 0) resistor r=0.5k
	r_282 (n_282 n_281 0) resistor r=0.5k
	r_281 (n_281 n_280 0) resistor r=0.5k
	r_280 (n_280 n_279 0) resistor r=0.5k
	r_279 (n_279 n_278 0) resistor r=0.5k
	r_278 (n_278 n_277 0) resistor r=0.5k
	r_277 (n_277 n_276 0) resistor r=0.5k
	r_276 (n_276 n_275 0) resistor r=0.5k
	r_275 (n_275 n_274 0) resistor r=0.5k
	r_274 (n_274 n_273 0) resistor r=0.5k
	r_273 (n_273 n_272 0) resistor r=0.5k
	r_272 (n_272 n_271 0) resistor r=0.5k
	r_271 (n_271 n_270 0) resistor r=0.5k
	r_270 (n_270 n_269 0) resistor r=0.5k
	r_269 (n_269 n_268 0) resistor r=0.5k
	r_268 (n_268 n_267 0) resistor r=0.5k
	r_267 (n_267 n_266 0) resistor r=0.5k
	r_266 (n_266 n_265 0) resistor r=0.5k
	r_265 (n_265 n_264 0) resistor r=0.5k
	r_264 (n_264 n_263 0) resistor r=0.5k
	r_263 (n_263 n_262 0) resistor r=0.5k
	r_262 (n_262 n_261 0) resistor r=0.5k
	r_261 (n_261 n_260 0) resistor r=0.5k
	r_260 (n_260 n_259 0) resistor r=0.5k
	r_259 (n_259 n_258 0) resistor r=0.5k
	r_258 (n_258 n_257 0) resistor r=0.5k
	r_257 (n_257 n_256 0) resistor r=0.5k
	r_256 (n_256 n_255 0) resistor r=0.5k
	r_255 (n_255 n_254 0) resistor r=0.5k
	r_254 (n_254 n_253 0) resistor r=0.5k
	r_253 (n_253 n_252 0) resistor r=0.5k
	r_252 (n_252 n_251 0) resistor r=0.5k
	r_251 (n_251 n_250 0) resistor r=0.5k
	r_250 (n_250 n_249 0) resistor r=0.5k
	r_249 (n_249 n_248 0) resistor r=0.5k
	r_248 (n_248 n_247 0) resistor r=0.5k
	r_247 (n_247 n_246 0) resistor r=0.5k
	r_246 (n_246 n_245 0) resistor r=0.5k
	r_245 (n_245 n_244 0) resistor r=0.5k
	r_244 (n_244 n_243 0) resistor r=0.5k
	r_243 (n_243 n_242 0) resistor r=0.5k
	r_242 (n_242 n_241 0) resistor r=0.5k
	r_241 (n_241 n_240 0) resistor r=0.5k
	r_240 (n_240 n_239 0) resistor r=0.5k
	r_239 (n_239 n_238 0) resistor r=0.5k
	r_238 (n_238 n_237 0) resistor r=0.5k
	r_237 (n_237 n_236 0) resistor r=0.5k
	r_236 (n_236 n_235 0) resistor r=0.5k
	r_235 (n_235 n_234 0) resistor r=0.5k
	r_234 (n_234 n_233 0) resistor r=0.5k
	r_233 (n_233 n_232 0) resistor r=0.5k
	r_232 (n_232 n_231 0) resistor r=0.5k
	r_231 (n_231 n_230 0) resistor r=0.5k
	r_230 (n_230 n_229 0) resistor r=0.5k
	r_229 (n_229 n_228 0) resistor r=0.5k
	r_228 (n_228 n_227 0) resistor r=0.5k
	r_227 (n_227 n_226 0) resistor r=0.5k
	r_226 (n_226 n_225 0) resistor r=0.5k
	r_225 (n_225 n_224 0) resistor r=0.5k
	r_224 (n_224 n_223 0) resistor r=0.5k
	r_223 (n_223 n_222 0) resistor r=0.5k
	r_222 (n_222 n_221 0) resistor r=0.5k
	r_221 (n_221 n_220 0) resistor r=0.5k
	r_220 (n_220 n_219 0) resistor r=0.5k
	r_219 (n_219 n_218 0) resistor r=0.5k
	r_218 (n_218 n_217 0) resistor r=0.5k
	r_217 (n_217 n_216 0) resistor r=0.5k
	r_216 (n_216 n_215 0) resistor r=0.5k
	r_215 (n_215 n_214 0) resistor r=0.5k
	r_214 (n_214 n_213 0) resistor r=0.5k
	r_213 (n_213 n_212 0) resistor r=0.5k
	r_212 (n_212 n_211 0) resistor r=0.5k
	r_211 (n_211 n_210 0) resistor r=0.5k
	r_210 (n_210 n_209 0) resistor r=0.5k
	r_209 (n_209 n_208 0) resistor r=0.5k
	r_208 (n_208 n_207 0) resistor r=0.5k
	r_207 (n_207 n_206 0) resistor r=0.5k
	r_206 (n_206 n_205 0) resistor r=0.5k
	r_205 (n_205 n_204 0) resistor r=0.5k
	r_204 (n_204 n_203 0) resistor r=0.5k
	r_203 (n_203 n_202 0) resistor r=0.5k
	r_202 (n_202 n_201 0) resistor r=0.5k
	r_201 (n_201 n_200 0) resistor r=0.5k
	r_200 (n_200 n_199 0) resistor r=0.5k
	r_199 (n_199 n_198 0) resistor r=0.5k
	r_198 (n_198 n_197 0) resistor r=0.5k
	r_197 (n_197 n_196 0) resistor r=0.5k
	r_196 (n_196 n_195 0) resistor r=0.5k
	r_195 (n_195 n_194 0) resistor r=0.5k
	r_194 (n_194 n_193 0) resistor r=0.5k
	r_193 (n_193 n_192 0) resistor r=0.5k
	r_192 (n_192 n_191 0) resistor r=0.5k
	r_191 (n_191 n_190 0) resistor r=0.5k
	r_190 (n_190 n_189 0) resistor r=0.5k
	r_189 (n_189 n_188 0) resistor r=0.5k
	r_188 (n_188 n_187 0) resistor r=0.5k
	r_187 (n_187 n_186 0) resistor r=0.5k
	r_186 (n_186 n_185 0) resistor r=0.5k
	r_185 (n_185 n_184 0) resistor r=0.5k
	r_184 (n_184 n_183 0) resistor r=0.5k
	r_183 (n_183 n_182 0) resistor r=0.5k
	r_182 (n_182 n_181 0) resistor r=0.5k
	r_181 (n_181 n_180 0) resistor r=0.5k
	r_180 (n_180 n_179 0) resistor r=0.5k
	r_179 (n_179 n_178 0) resistor r=0.5k
	r_178 (n_178 n_177 0) resistor r=0.5k
	r_177 (n_177 n_176 0) resistor r=0.5k
	r_176 (n_176 n_175 0) resistor r=0.5k
	r_175 (n_175 n_174 0) resistor r=0.5k
	r_174 (n_174 n_173 0) resistor r=0.5k
	r_173 (n_173 n_172 0) resistor r=0.5k
	r_172 (n_172 n_171 0) resistor r=0.5k
	r_171 (n_171 n_170 0) resistor r=0.5k
	r_170 (n_170 n_169 0) resistor r=0.5k
	r_169 (n_169 n_168 0) resistor r=0.5k
	r_168 (n_168 n_167 0) resistor r=0.5k
	r_167 (n_167 n_166 0) resistor r=0.5k
	r_166 (n_166 n_165 0) resistor r=0.5k
	r_165 (n_165 n_164 0) resistor r=0.5k
	r_164 (n_164 n_163 0) resistor r=0.5k
	r_163 (n_163 n_162 0) resistor r=0.5k
	r_162 (n_162 n_161 0) resistor r=0.5k
	r_161 (n_161 n_160 0) resistor r=0.5k
	r_160 (n_160 n_159 0) resistor r=0.5k
	r_159 (n_159 n_158 0) resistor r=0.5k
	r_158 (n_158 n_157 0) resistor r=0.5k
	r_157 (n_157 n_156 0) resistor r=0.5k
	r_156 (n_156 n_155 0) resistor r=0.5k
	r_155 (n_155 n_154 0) resistor r=0.5k
	r_154 (n_154 n_153 0) resistor r=0.5k
	r_153 (n_153 n_152 0) resistor r=0.5k
	r_152 (n_152 n_151 0) resistor r=0.5k
	r_151 (n_151 n_150 0) resistor r=0.5k
	r_150 (n_150 n_149 0) resistor r=0.5k
	r_149 (n_149 n_148 0) resistor r=0.5k
	r_148 (n_148 n_147 0) resistor r=0.5k
	r_147 (n_147 n_146 0) resistor r=0.5k
	r_146 (n_146 n_145 0) resistor r=0.5k
	r_145 (n_145 n_144 0) resistor r=0.5k
	r_144 (n_144 n_143 0) resistor r=0.5k
	r_143 (n_143 n_142 0) resistor r=0.5k
	r_142 (n_142 n_141 0) resistor r=0.5k
	r_141 (n_141 n_140 0) resistor r=0.5k
	r_140 (n_140 n_139 0) resistor r=0.5k
	r_139 (n_139 n_138 0) resistor r=0.5k
	r_138 (n_138 n_137 0) resistor r=0.5k
	r_137 (n_137 n_136 0) resistor r=0.5k
	r_136 (n_136 n_135 0) resistor r=0.5k
	r_135 (n_135 n_134 0) resistor r=0.5k
	r_134 (n_134 n_133 0) resistor r=0.5k
	r_133 (n_133 n_132 0) resistor r=0.5k
	r_132 (n_132 n_131 0) resistor r=0.5k
	r_131 (n_131 n_130 0) resistor r=0.5k
	r_130 (n_130 n_129 0) resistor r=0.5k
	r_129 (n_129 n_128 0) resistor r=0.5k
	r_128 (n_128 n_127 0) resistor r=0.5k
	r_127 (n_127 n_126 0) resistor r=0.5k
	r_126 (n_126 n_125 0) resistor r=0.5k
	r_125 (n_125 n_124 0) resistor r=0.5k
	r_124 (n_124 n_123 0) resistor r=0.5k
	r_123 (n_123 n_122 0) resistor r=0.5k
	r_122 (n_122 n_121 0) resistor r=0.5k
	r_121 (n_121 n_120 0) resistor r=0.5k
	r_120 (n_120 n_119 0) resistor r=0.5k
	r_119 (n_119 n_118 0) resistor r=0.5k
	r_118 (n_118 n_117 0) resistor r=0.5k
	r_117 (n_117 n_116 0) resistor r=0.5k
	r_116 (n_116 n_115 0) resistor r=0.5k
	r_115 (n_115 n_114 0) resistor r=0.5k
	r_114 (n_114 n_113 0) resistor r=0.5k
	r_113 (n_113 n_112 0) resistor r=0.5k
	r_112 (n_112 n_111 0) resistor r=0.5k
	r_111 (n_111 n_110 0) resistor r=0.5k
	r_110 (n_110 n_109 0) resistor r=0.5k
	r_109 (n_109 n_108 0) resistor r=0.5k
	r_108 (n_108 n_107 0) resistor r=0.5k
	r_107 (n_107 n_106 0) resistor r=0.5k
	r_106 (n_106 n_105 0) resistor r=0.5k
	r_105 (n_105 n_104 0) resistor r=0.5k
	r_104 (n_104 n_103 0) resistor r=0.5k
	r_103 (n_103 n_102 0) resistor r=0.5k
	r_102 (n_102 n_101 0) resistor r=0.5k
	r_101 (n_101 n_100 0) resistor r=0.5k
	r_100 (n_100 n_99 0) resistor r=0.5k
	r_99 (n_99 n_98 0) resistor r=0.5k
	r_98 (n_98 n_97 0) resistor r=0.5k
	r_97 (n_97 n_96 0) resistor r=0.5k
	r_96 (n_96 n_95 0) resistor r=0.5k
	r_95 (n_95 n_94 0) resistor r=0.5k
	r_94 (n_94 n_93 0) resistor r=0.5k
	r_93 (n_93 n_92 0) resistor r=0.5k
	r_92 (n_92 n_91 0) resistor r=0.5k
	r_91 (n_91 n_90 0) resistor r=0.5k
	r_90 (n_90 n_89 0) resistor r=0.5k
	r_89 (n_89 n_88 0) resistor r=0.5k
	r_88 (n_88 n_87 0) resistor r=0.5k
	r_87 (n_87 n_86 0) resistor r=0.5k
	r_86 (n_86 n_85 0) resistor r=0.5k
	r_85 (n_85 n_84 0) resistor r=0.5k
	r_84 (n_84 n_83 0) resistor r=0.5k
	r_83 (n_83 n_82 0) resistor r=0.5k
	r_82 (n_82 n_81 0) resistor r=0.5k
	r_81 (n_81 n_80 0) resistor r=0.5k
	r_80 (n_80 n_79 0) resistor r=0.5k
	r_79 (n_79 n_78 0) resistor r=0.5k
	r_78 (n_78 n_77 0) resistor r=0.5k
	r_77 (n_77 n_76 0) resistor r=0.5k
	r_76 (n_76 n_75 0) resistor r=0.5k
	r_75 (n_75 n_74 0) resistor r=0.5k
	r_74 (n_74 n_73 0) resistor r=0.5k
	r_73 (n_73 n_72 0) resistor r=0.5k
	r_72 (n_72 n_71 0) resistor r=0.5k
	r_71 (n_71 n_70 0) resistor r=0.5k
	r_70 (n_70 n_69 0) resistor r=0.5k
	r_69 (n_69 n_68 0) resistor r=0.5k
	r_68 (n_68 n_67 0) resistor r=0.5k
	r_67 (n_67 n_66 0) resistor r=0.5k
	r_66 (n_66 n_65 0) resistor r=0.5k
	r_65 (n_65 n_64 0) resistor r=0.5k
	r_64 (n_64 n_63 0) resistor r=0.5k
	r_63 (n_63 n_62 0) resistor r=0.5k
	r_62 (n_62 n_61 0) resistor r=0.5k
	r_61 (n_61 n_60 0) resistor r=0.5k
	r_60 (n_60 n_59 0) resistor r=0.5k
	r_59 (n_59 n_58 0) resistor r=0.5k
	r_58 (n_58 n_57 0) resistor r=0.5k
	r_57 (n_57 n_56 0) resistor r=0.5k
	r_56 (n_56 n_55 0) resistor r=0.5k
	r_55 (n_55 n_54 0) resistor r=0.5k
	r_54 (n_54 n_53 0) resistor r=0.5k
	r_53 (n_53 n_52 0) resistor r=0.5k
	r_52 (n_52 n_51 0) resistor r=0.5k
	r_51 (n_51 n_50 0) resistor r=0.5k
	r_50 (n_50 n_49 0) resistor r=0.5k
	r_49 (n_49 n_48 0) resistor r=0.5k
	r_48 (n_48 n_47 0) resistor r=0.5k
	r_47 (n_47 n_46 0) resistor r=0.5k
	r_46 (n_46 n_45 0) resistor r=0.5k
	r_45 (n_45 n_44 0) resistor r=0.5k
	r_44 (n_44 n_43 0) resistor r=0.5k
	r_43 (n_43 n_42 0) resistor r=0.5k
	r_42 (n_42 n_41 0) resistor r=0.5k
	r_41 (n_41 n_40 0) resistor r=0.5k
	r_40 (n_40 n_39 0) resistor r=0.5k
	r_39 (n_39 n_38 0) resistor r=0.5k
	r_38 (n_38 n_37 0) resistor r=0.5k
	r_37 (n_37 n_36 0) resistor r=0.5k
	r_36 (n_36 n_35 0) resistor r=0.5k
	r_35 (n_35 n_34 0) resistor r=0.5k
	r_34 (n_34 n_33 0) resistor r=0.5k
	r_33 (n_33 n_32 0) resistor r=0.5k
	r_32 (n_32 n_31 0) resistor r=0.5k
	r_31 (n_31 n_30 0) resistor r=0.5k
	r_30 (n_30 n_29 0) resistor r=0.5k
	r_29 (n_29 n_28 0) resistor r=0.5k
	r_28 (n_28 n_27 0) resistor r=0.5k
	r_27 (n_27 n_26 0) resistor r=0.5k
	r_26 (n_26 n_25 0) resistor r=0.5k
	r_25 (n_25 n_24 0) resistor r=0.5k
	r_24 (n_24 n_23 0) resistor r=0.5k
	r_23 (n_23 n_22 0) resistor r=0.5k
	r_22 (n_22 n_21 0) resistor r=0.5k
	r_21 (n_21 n_20 0) resistor r=0.5k
	r_20 (n_20 n_19 0) resistor r=0.5k
	r_19 (n_19 n_18 0) resistor r=0.5k
	r_18 (n_18 n_17 0) resistor r=0.5k
	r_17 (n_17 n_16 0) resistor r=0.5k
	r_16 (n_16 n_15 0) resistor r=0.5k
	r_15 (n_15 n_14 0) resistor r=0.5k
	r_14 (n_14 n_13 0) resistor r=0.5k
	r_13 (n_13 n_12 0) resistor r=0.5k
	r_12 (n_12 n_11 0) resistor r=0.5k
	r_11 (n_11 n_10 0) resistor r=0.5k
	r_10 (n_10 n_9 0) resistor r=0.5k
	r_9 (n_9 n_8 0) resistor r=0.5k
	r_8 (n_8 n_7 0) resistor r=0.5k
	r_7 (n_7 n_6 0) resistor r=0.5k
	r_6 (n_6 n_5 0) resistor r=0.5k
	r_5 (n_5 n_4 0) resistor r=0.5k
	r_4 (n_4 n_3 0) resistor r=0.5k
	r_3 (n_3 n_2 0) resistor r=0.5k
	r_2 (n_2 n_1 0) resistor r=0.5k
	r_1 (n_1 n_0 0) resistor r=0.5k
	r_0 (n_0 0 0) resistor r=0.5k

	// analog_mux connection

	m_0 (n_511 n_510
		+ n_509 n_508 n_507 n_506 n_505 n_504 n_503 n_502 n_501 n_500
		+ n_499 n_498 n_497 n_496 n_495 n_494 n_493 n_492 n_491 n_490
		+ n_489 n_488 n_487 n_486 n_485 n_484 n_483 n_482 n_481 n_480
		+ n_479 n_478 n_477 n_476 n_475 n_474 n_473 n_472 n_471 n_470
		+ n_469 n_468 n_467 n_466 n_465 n_464 n_463 n_462 n_461 n_460
		+ n_459 n_458 n_457 n_456 n_455 n_454 n_453 n_452 n_451 n_450
		+ n_449 n_448 n_447 n_446 n_445 n_444 n_443 n_442 n_441 n_440
		+ n_439 n_438 n_437 n_436 n_435 n_434 n_433 n_432 n_431 n_430
		+ n_429 n_428 n_427 n_426 n_425 n_424 n_423 n_422 n_421 n_420
		+ n_419 n_418 n_417 n_416 n_415 n_414 n_413 n_412 n_411 n_410
		+ n_409 n_408 n_407 n_406 n_405 n_404 n_403 n_402 n_401 n_400
		+ n_399 n_398 n_397 n_396 n_395 n_394 n_393 n_392 n_391 n_390
		+ n_389 n_388 n_387 n_386 n_385 n_384 n_383 n_382 n_381 n_380
		+ n_379 n_378 n_377 n_376 n_375 n_374 n_373 n_372 n_371 n_370
		+ n_369 n_368 n_367 n_366 n_365 n_364 n_363 n_362 n_361 n_360
		+ n_359 n_358 n_357 n_356 n_355 n_354 n_353 n_352 n_351 n_350
		+ n_349 n_348 n_347 n_346 n_345 n_344 n_343 n_342 n_341 n_340
		+ n_339 n_338 n_337 n_336 n_335 n_334 n_333 n_332 n_331 n_330
		+ n_329 n_328 n_327 n_326 n_325 n_324 n_323 n_322 n_321 n_320
		+ n_319 n_318 n_317 n_316 n_315 n_314 n_313 n_312 n_311 n_310
		+ n_309 n_308 n_307 n_306 n_305 n_304 n_303 n_302 n_301 n_300
		+ n_299 n_298 n_297 n_296 n_295 n_294 n_293 n_292 n_291 n_290
		+ n_289 n_288 n_287 n_286 n_285 n_284 n_283 n_282 n_281 n_280
		+ n_279 n_278 n_277 n_276 n_275 n_274 n_273 n_272 n_271 n_270
		+ n_269 n_268 n_267 n_266 n_265 n_264 n_263 n_262 n_261 n_260
		+ n_259 n_258 n_257 n_256 n_255 n_254 n_253 n_252 n_251 n_250
		+ n_249 n_248 n_247 n_246 n_245 n_244 n_243 n_242 n_241 n_240
		+ n_239 n_238 n_237 n_236 n_235 n_234 n_233 n_232 n_231 n_230
		+ n_229 n_228 n_227 n_226 n_225 n_224 n_223 n_222 n_221 n_220
		+ n_219 n_218 n_217 n_216 n_215 n_214 n_213 n_212 n_211 n_210
		+ n_209 n_208 n_207 n_206 n_205 n_204 n_203 n_202 n_201 n_200
		+ n_199 n_198 n_197 n_196 n_195 n_194 n_193 n_192 n_191 n_190
		+ n_189 n_188 n_187 n_186 n_185 n_184 n_183 n_182 n_181 n_180
		+ n_179 n_178 n_177 n_176 n_175 n_174 n_173 n_172 n_171 n_170
		+ n_169 n_168 n_167 n_166 n_165 n_164 n_163 n_162 n_161 n_160
		+ n_159 n_158 n_157 n_156 n_155 n_154 n_153 n_152 n_151 n_150
		+ n_149 n_148 n_147 n_146 n_145 n_144 n_143 n_142 n_141 n_140
		+ n_139 n_138 n_137 n_136 n_135 n_134 n_133 n_132 n_131 n_130
		+ n_129 n_128 n_127 n_126 n_125 n_124 n_123 n_122 n_121 n_120
		+ n_119 n_118 n_117 n_116 n_115 n_114 n_113 n_112 n_111 n_110
		+ n_109 n_108 n_107 n_106 n_105 n_104 n_103 n_102 n_101 n_100
		+ n_99 n_98 n_97 n_96 n_95 n_94 n_93 n_92 n_91 n_90
		+ n_89 n_88 n_87 n_86 n_85 n_84 n_83 n_82 n_81 n_80
		+ n_79 n_78 n_77 n_76 n_75 n_74 n_73 n_72 n_71 n_70
		+ n_69 n_68 n_67 n_66 n_65 n_64 n_63 n_62 n_61 n_60
		+ n_59 n_58 n_57 n_56 n_55 n_54 n_53 n_52 n_51 n_50
		+ n_49 n_48 n_47 n_46 n_45 n_44 n_43 n_42 n_41 n_40
		+ n_39 n_38 n_37 n_36 n_35 n_34 n_33 n_32 n_31 n_30
		+ n_29 n_28 n_27 n_26 n_25 n_24 n_23 n_22 n_21 n_20
		+ n_19 n_18 n_17 n_16 n_15 n_14 n_13 n_12 n_11 n_10
		+ n_9 n_8 n_7 n_6 n_5 n_4 n_3 n_2 n_1 n_0
		+  to_rram sel) analog_mux

ends resistive_loads
