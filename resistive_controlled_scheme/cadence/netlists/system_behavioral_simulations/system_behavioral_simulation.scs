simulator lang=spectre

// Start of sensible_nodes_sweep (sweep) analysis
// rram_sweep sweep param=p_level start=0 stop=p_total_levels step=1{
// rram_sweep sweep param=p_tx_p_l start=40n stop=1.5u dec=5{
	// Start of reliability_framework_tran (tran) analysis
	reliability_framework_tran tran save=selected stop=p_sim_time
		+ method=gear2only annotate=no maxiters=5
		// + maxstep=p_max_step
		// + paramset=psettiming
// } // end sweep

// New options
simulatorOptions options temp=p_temp tnom=27 scale=1.0 gmin=1e-12 rforce=1 maxnotes=5 maxwarns=5 digits=5 cols=80
	////////////////////////////////////////////////
	// Additional convergence options,  if needed //
	////////////////////////////////////////////////
		// + reltol=1e-9 vabstol=1e-10 iabstol=1e-12
		// + reltol=1e-8 vabstol=1e-9 iabstol=1e-11
		// + pivrel=1e-3 reltol=1e-10 vabstol=1e-10 iabstol=1e-13 // used for characterization
		// + pivrel=1e-3 reltol=1e-10 vabstol=1e-10 iabstol=1e-13

/////////////////
//Save options //
/////////////////
saveOptions options save=all saveahdlvars=all

////////////////////
//Save statements //
////////////////////

save clk
save start_op
save counter_0
save fsm_0
save fsm_1
save EN_RESET
save EN_SET
save END_RESET

save ADD
save ADD_0
save ADD_1

save V_RAW
save V_RESET
save V_SET
save V_WR
save V_LOAD
save V_SEL
save LEV

save n_col_0
save n_col_1
save n_col_2
save n_sel_0
save n_sel_1
save n_sel_2
save n_drain_0
save n_drain_1
save n_drain_2

save rl_0.n_0
save rl_0.n_1
save rl_0.n_2
save rl_0.n_3
save rl_0.n_4
save rl_0.n_5
save rl_0.n_6
save rl_0.n_7
save rl_0.n_8
save rl_0.n_9
save rl_0.n_10
save rl_0.n_11
save rl_0.n_12
save rl_0.n_13
save rl_0.n_14
save rl_0.n_15
save rl_0.n_16
save rl_0.n_17
save rl_0.n_18
save rl_0.n_19
save rl_0.n_20
save rl_0.n_21
save rl_0.n_22
save rl_0.n_23
save rl_0.n_24
save rl_0.n_25
save rl_0.n_26
save rl_0.n_27
save rl_0.n_28
save rl_0.n_29
save rl_0.n_30
save rl_0.n_31

save rl_0.n_en_reset
save rl_0.m_0.n_in
save rl_0.m_0.n_en_reset
save rl_0.m_0.n_en_set

save counter_0

save col_demux
save rram_11.mem_0:rram_r_read
save rram_11.mem_0:rram_r_read
save rram_11.mem_0:rram_temperature
