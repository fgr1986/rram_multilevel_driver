simulator lang=spectre

ahdl_include "1t1r_g_idx_5_analog_mux.va"

//////////////////////////////////
// Resistive loads and analog_mux cell //
// v1.0 01/11/2017              //
//////////////////////////////////

subckt resistive_loads (to_rram n_en_reset)

	// optimized for 1t1rcell,
	// inital gaps at 1.7e-09
	// and 32 levels

	parameters mux_level=0
	r_31 (n_31 n_30) resistor r=p_r0*146500.0
	r_30 (n_30 n_29) resistor r=p_r0*8750.0
	r_29 (n_29 n_28) resistor r=p_r0*4500.0
	r_28 (n_28 n_27) resistor r=p_r0*3000.0
	r_27 (n_27 n_26) resistor r=p_r0*2000.0
	r_26 (n_26 n_25) resistor r=p_r0*1750.0
	r_25 (n_25 n_24) resistor r=p_r0*1500.0
	r_24 (n_24 n_23) resistor r=p_r0*1000.0
	r_23 (n_23 n_22) resistor r=p_r0*1000.0
	r_22 (n_22 n_21) resistor r=p_r0*750.0
	r_21 (n_21 n_20) resistor r=p_r0*750.0
	r_20 (n_20 n_19) resistor r=p_r0*750.0
	r_19 (n_19 n_18) resistor r=p_r0*750.0
	r_18 (n_18 n_17) resistor r=p_r0*500.0
	r_17 (n_17 n_16) resistor r=p_r0*750.0
	r_16 (n_16 n_15) resistor r=p_r0*500.0
	r_15 (n_15 n_14) resistor r=p_r0*750.0
	r_14 (n_14 n_13) resistor r=p_r0*750.0
	r_13 (n_13 n_12) resistor r=p_r0*750.0
	r_12 (n_12 n_11) resistor r=p_r0*1000.0
	r_11 (n_11 n_10) resistor r=p_r0*1000.0
	r_10 (n_10 n_9) resistor r=p_r0*1500.0
	r_9 (n_9 n_8) resistor r=p_r0*2000.0
	r_8 (n_8 n_7) resistor r=p_r0*2500.0
	r_7 (n_7 n_6) resistor r=p_r0*4000.0
	r_6 (n_6 n_5) resistor r=p_r0*5250.0
	r_5 (n_5 n_4) resistor r=p_r0*7000.0
	r_4 (n_4 n_3) resistor r=p_r0*9500.0
	r_3 (n_3 n_2) resistor r=p_r0*11750.0
	r_2 (n_2 n_1) resistor r=p_r0*5500.0
	r_1 (n_1 n_0) resistor r=p_r0*27750.0
	r_0 (n_0 0) resistor r=p_r0*250.0

	// analog_mux connection

	m_0 (n_31 n_30
		+ n_29 n_28 n_27 n_26 n_25 n_24 n_23 n_22 n_21 n_20
		+ n_19 n_18 n_17 n_16 n_15 n_14 n_13 n_12 n_11 n_10
		+ n_9 n_8 n_7 n_6 n_5 n_4 n_3 n_2 n_1 n_0
		+  to_rram n_en_reset) analog_mux level=mux_level

ends resistive_loads
