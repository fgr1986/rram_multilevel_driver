////////////////////////////
// Single rram experiment //
// v0.1 28/09/2017        //
////////////////////////////

simulator lang=spectre
global 0 vdd! vss!

// Including parsed model. Original: '/opt/technology/tsmc40nm_18/models/spectre/toplevel.scs'
// top_localmconly top_tt
// include "/opt/technology/tsmc40nm_18/models/spectre/toplevel.scs" section=top_localmconly
include "/eda/technologies/tsmc_40nm/pdk/models/spectre/toplevel.scs" section=top_tt

include "../ommit/arizona_rram_cells.scs"
include "../ommit/driver_characterization_circuitry/loads_subcircuit.scs"
include "driver_characterization_simulations.scs"

// Parameters
parameters

// simulation
+ p_sim_time=30n + p_write_length
// + p_max_step=10p
// + p_max_step=1000p
// temperature
+ p_T0=300
+ p_temp=(p_T0-273.15) // in celsius

// rram initial state
+ p_gamma0=16.5
+ p_rram_seed=p_level
+ p_rram_variab=0

// clip resistance range or full range
+ p_clip=0
// gap selection
+ p_gap_idx=3
// Initial state
+ p_rram_gap_ini_0b = p_gap_idx<1 ? 1.2e-9 :
			+ p_gap_idx<2 ? 1.3e-9 :
			+ p_gap_idx<3 ? 1.367e-9 :
			+ p_gap_idx<4 ? 1.5e-9 :
			+ p_gap_idx<5 ? 1.6e-9 :
			+ 1.7e-9
// check boundaries
+ p_rram_gap_ini_0 = max(0.1e-9, min(p_rram_gap_ini_0b, 1.7e-9))

// level
+ p_level=5
// + p_total_levels=1024-1 // for sweep
+ p_total_levels=2048-1 // for sweep

// resistances
// p_r0 adds variability to loads and control loads
+ p_r0=1

// vdd
+ p_vdd=1.8
// write pulse
+ p_up=0.5n p_fall=0.5n p_delay=10n p_write_length=100n
// write amp nominal
+ p_v_set=2 // fom simulations
// + p_write_amp=2*p_v_set
// V_write
// + p_write_amp= p_level<p_total_levels ? 2*p_v_set : (p_clip<1 ? 0 : 2*p_v_set)
+ p_write_amp= 1*p_v_set

// transistor
// + tx_p_l=3000n
// + tx_p_w=120n
+ tx_p_l=40n
+ tx_p_w=120n

// voltage supply
VDD      ( vdd!     0 ) vsource dc=p_vdd type=dc
VSS      ( vss!     0 ) vsource dc=0     type=dc

// write voltage (pulse)
V0 (n_write 0) vsource type=pulse delay=p_delay val0=0 val1=p_write_amp rise=p_up fall=p_fall width=p_write_length

////////////////////////////
// Write circuit
////////////////////////////

// gate control
v_aux  (n_gate         0) bsource v= 1.8 //v(n_write)>0.5 ? p_vdd : 0
v_aux2 (n_gate_loads   0) bsource v= 1.8
// v_aux3 (n_gate_loads_b 0) bsource v= 0
// tx_a (vdd! to_rram n_gate_loads vdd!) pch_mac l=tx_p_l w=2*tx_p_w m=1 nf=1
// tx_b (0    to_rram n_gate_loads 0)    nch_mac l=tx_p_l w=2*tx_p_w m=1 nf=1
//
// ic n_gate_loads=p_vdd

// 1T1R with parasitics rram_cell_1t1r
// rram_0 (n_write n_to_rram n_gate)  rram_cell_1t1r rram_variab=p_rram_variab rram_seed=p_rram_seed rram_T0=p_T0 rram_gamma0=p_gamma0 rram_gap_ini=p_rram_gap_ini_0
rram_0 (n_write n_to_rram n_gate)  rram_cell_1t1r rram_variab=p_rram_variab rram_seed=p_rram_seed rram_T0=p_T0 rram_gamma0=p_gamma0 rram_gap_ini=p_rram_gap_ini_0

// resistor loads
// (source gate drain bulk)
// rl_0 (n_to_rram) tx_loads mux_level=p_level

// rl_0 (n_to_rram 0) resistor r=5k
cl_0 (n_to_rram 0) capacitor c=p_level*5f
// tx_15n (vdd! n_to_rram 0 vdd!) pch_mac l=tx_p_l w=tx_p_w m=1 nf=1

// tx_15n (n_to_rram n_gate_loads   0 0) nch_mac l=tx_p_l w=tx_p_w m=1 nf=1
// tx_14n (n_to_rram n_gate_loads   0 0) nch_mac l=tx_p_l w=tx_p_w m=1 nf=1
// tx_13n (n_to_rram n_gate_loads   0 0) nch_mac l=tx_p_l w=tx_p_w m=1 nf=1
// tx_12n (n_to_rram n_gate_loads   0 0) nch_mac l=tx_p_l w=tx_p_w m=1 nf=1
// tx_11n (n_to_rram n_gate_loads   0 0) nch_mac l=tx_p_l w=tx_p_w m=1 nf=1
// tx_10n (n_to_rram n_gate_loads   0 0) nch_mac l=tx_p_l w=tx_p_w m=1 nf=1
// tx_9n  (n_to_rram n_gate_loads   0 0) nch_mac l=tx_p_l w=tx_p_w m=1 nf=1
// tx_8n  (n_to_rram n_gate_loads   0 0) nch_mac l=tx_p_l w=tx_p_w m=1 nf=1
// tx_7n  (n_to_rram n_gate_loads   0 0) nch_mac l=tx_p_l w=tx_p_w m=1 nf=1
// tx_6n  (n_to_rram n_gate_loads   0 0) nch_mac l=tx_p_l w=tx_p_w m=1 nf=1
// tx_5n  (n_to_rram n_gate_loads   0 0) nch_mac l=tx_p_l w=tx_p_w m=1 nf=1
// tx_4n  (n_to_rram n_gate_loads   0 0) nch_mac l=tx_p_l w=tx_p_w m=1 nf=1
// tx_3n  (n_to_rram n_gate_loads   0 0) nch_mac l=tx_p_l w=tx_p_w m=1 nf=1
// tx_2n  (n_to_rram n_gate_loads   0 0) nch_mac l=tx_p_l w=tx_p_w m=1 nf=1
// tx_1n  (n_to_rram n_gate_loads   0 0) nch_mac l=tx_p_l w=tx_p_w m=1 nf=1
// tx_0n  (n_to_rram n_gate_loads   0 0) nch_mac l=tx_p_l w=tx_p_w m=1 nf=1
