  // V 0.1
  // Library name: tvlsi_multilevel
  // Cell name: reset_comparator_module
  // View name: schematic

simulator lang=spectre

// include "/opt/technology/tsmc40nm_18/tsmcN40/../models/spectre/toplevel.scs" section=top_tt
subckt reset_comparator_module (vin1 vin2 vout)

parameters pI=8u p_INV_NW=320n p_INV_PW=640n p_NL=150n p_NW=2400n p_PL=850n p_PW=320n

  M6 (vout2 vout1 vdd! vdd!) pch_18_mac l=150.0n w=p_INV_PW*1 m=1 nf=1
  M3 (vout1b vout1b vdd! vdd!) pch_18_mac l=p_PL w=p_PW*1 m=1 nf=1
  M5 (vout1 vout1b vdd! vdd!) pch_18_mac l=p_PL w=p_PW*1 m=1 nf=1
  M0 (vout1b vin1 VP 0) nch_18_mac l=p_NL w=p_NW*1 m=1 nf=1
  M4 (vout2 vout1 0 0) nch_18_mac l=150.0n w=p_INV_NW*1 m=1 nf=1
  M2 (vout1 vin2 VP 0) nch_18_mac l=p_NL w=p_NW*1 m=1 nf=1
  I12 (VP 0) isource dc=pI type=dc

  M8 (vout vout2 vdd! vdd!) pch_18_mac l=150.0n w=p_INV_PW*1 m=1 nf=1
  M7 (vout vout2 0 0) nch_18_mac l=150.0n w=p_INV_NW*1 m=1 nf=1

  // V1 (vdd! 0) vsource dc=1.8 type=dc
  // C0 (vout 0) capacitor c=10f
  // V0 (vin1 0) vsource dc=-530m type=dc
  // V2 (vin2 0) vsource dc=-530m type=sine freq=20M ampl=10m

ends reset_comparator_module
