simulator lang=spectre
global 0 vdd!

// should be included by the framework
// include "/opt/technology/tsmc40nm_18/tsmcN40/../models/spectre/toplevel.scs" section=top_tt
include "/opt/technology/tsmc40nm_18/tsmcN40/../models/spectre/toplevel.scs" section=top_tt
// include "/opt/technology/tsmc40nm_18/tsmcN40/../models/spectre/toplevel.scs" section=top_globalmc_localmc

// ahdl_include "Control.va"
include "rram_1t1r_nch_11_cell_custom_parasitics.scs"
// include "reset_comparator_module.scs"

parameters
  + p_sim_time=0.2u
  + p_T0=300
  + p_temp=p_T0-273.15

  + p_gate_driver=0.8
  + p_i=1e-9

  + p_rram_tstep=1p
  + P_rram_T0=300
  + P_rram_Vread=0.1

  // + p_gap_ini=1.367e-9
  + p_gap_ini=0.1e-9

    // pulses
    + V_STOP_1=1.8
    + V_STOP_2=-1.8
    + v_reset_width=50n
    + v_set_width=100n
    + V_RISE=5n
    + p_gate=1.8

    + p_pI=8u

  ///////////////
  // VDD
  ///////////////
  V_VDD (vdd! 0) vsource dc=1.8 type=dc

  ///////////////
  // Reset
  ///////////////
  // Reset
  breset (rram_block_out 0) isource type=pulse val0=0 val1=-p_pI delay=0n period=5*v_set_width rise=1n fall=1n width=v_set_width
  v0 (rram_block_in 0) vsource type=pwl pwlperiod=p_sim_time wave=[ 0 0 1n V_STOP_2 200n V_STOP_2 ]

  ///////////////
  // RRAM
  ///////////////
  // RRAM Selector
  v_sel (rram_sel 0) bsource v=v(reset_enable)
  // rram
  rram_0 ( rram_block_in rram_block_out rram_sel ) rram_1t1r_nch_11_cell rram_gap_ini=p_gap_ini

  // ANALYSIS
  // by simulation

  // my_tran tran stop=p_sim_time method=trap annotate=no maxiters=5

  // Start of sensible_nodes_montecarlo (montecarlo) analysis
  //sensible_nodes_montecarlo montecarlo variations=all donominal=no savefamilyplots=yes firstrun=1 seed=1 numruns=50 {
    //sweep_driver_gate_v sweep param=p_gate_driver values= [ 0 0.8 0.85 0.88 0.9 0.915  0.95 1.8 ] {
    sweep_driver_gate_v sweep param=p_pI values= [ 270u 272u 274u 276u 278u ] {
      my_tran tran stop=p_sim_time method=trap annotate=no maxiters=5
    }
  //}
  // End of sensible_nodes_montecarlo (montecarlo ) analysis

saveOptions options  save=allpub  saveahdlvars=all

simulatorOptions options genmcdep=yes reltol=1e-3 vabstol=1e-6 iabstol=1e-12 temp=p_temp tnom=27 scale=1.0 gmin=1e-12 rforce=1 maxnotes=5 maxwarns=5 digits=5 cols=80 pivrel=1e-3
save rram_block_in
save rram_sel
save reset_sel_driver

save BDriver_0:1
save txDriver_0:1

save rram_0.mem0:R_out
save rram_0.mem0:gap
save rram_0.txN0:1
save rram_0.aux_mem0_volt
