simulator lang=spectre
global 0 vdd!

// ahdl_include "/opt/technology/rram/arizona_imec/rram.va"
include "rram_synapse.scs"
// should be included by the framework
include "/opt/technology/tsmc40nm_18/tsmcN40/../models/spectre/toplevel.scs" section=top_tt
//include "/opt/technology/tsmc40nm_25/tsmcN40/../models/spectre/toplevel.scs" section=top_tt

parameters
  + p_sim_time=0.2u
  + p_T0=300
  + p_temp=p_T0-273.15

  + p_nchL=40n
  + p_nchW=600n
  + p_gate_driver=1.8
  + p_i=1e-9

  + p_rram_tstep=1p
  + P_rram_T0=300
  + P_rram_Vread=0.1

  + p_rram_1r_cells_gap_ini=1.367e-9
  // + p_rram_1r_cells_gap_ini=0.1e-9

    // pulses
    + V_WIDTH=100n
    + V_RISE=5n
    + p_in=1.8

  // voltage
  v0 (rram_block_in 0) vsource type=pulse val0=0 val1=p_in period=5*V_WIDTH rise=V_RISE fall=V_RISE width=V_WIDTH

  // rram
  rram_0 ( rram_block_in 0 ) rram_synapse rram_gap_ini=p_rram_1r_cells_gap_ini

   // default voltages
   // varying stop voltage
   // [0 -1.48 -1.55 -1.6 -1.65 -1.7 -1.75 -1.8]
   // varying gate voltage
   sweep_driver_gate_v sweep param=p_in values=[0 0.4 0.8 1.2 1.6 1.8] {
     my_tran tran stop=p_sim_time method=trap annotate=no maxiters=5
   }

// ANALYSIS
// by simulation

saveOptions options  save=allpub  saveahdlvars=all

simulatorOptions options genmcdep=yes reltol=1e-3 vabstol=1e-6 iabstol=1e-12 temp=p_temp tnom=27 scale=1.0 gmin=1e-12 rforce=1 maxnotes=5 maxwarns=5 digits=5 cols=80 pivrel=1e-3
save rram_block_in
save rram_sel_driver
save rram_sel
save BDriver_0:1
save txDriver_0:1

save rram_0.mem0:R_out
save rram_0.mem0:gap
save rram_0.txN0:1
save rram_0.aux_mem0_volt
